// VerilogA for verilog_a_test4, NOR_GATE;, veriloga

`include "constants.vams"
`include "disciplines.vams"

module NOR_GATE(in1, in2, out, vdd, gnd, bulk);
  inout in1, in2, out, vdd, gnd, bulk;
  electrical in1, in2, out, vdd, gnd, bulk;

electrical node1;

SFED sfed1 (.d(vdd), .gs(gnd), .gd(in1), .s(node1), .b(bulk));
SFED sfed2 (.d(node1), .gs(gnd), .gd(in2), .s(out), .b(bulk));
SFED sfed3 (.d(out), .gs(in2), .gd(vdd), .s(gnd), .b(bulk));
SFED sfed4 (.d(out), .gs(in1), .gd(vdd), .s(gnd), .b(bulk));

endmodule
