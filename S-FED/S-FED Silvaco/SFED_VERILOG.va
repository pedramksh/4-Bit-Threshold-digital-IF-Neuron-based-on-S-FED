`include "constants.vams"
`include "disciplines.vams"

module SFED(d, gs, gd, s, b);
    inout d, gs, gd, s, b; // Drain, Gates, Source , Bulk
    electrical d, gs, gd, s, b;

    localparam integer vds_width_int = 121;
    parameter real vds_points[0:vds_width_int-1] =  // Vds range in volts
	{
		0.0000000000e+00,
		1.0000000000e-02,
		2.0000000000e-02,
		3.0000000000e-02,
		4.0000000000e-02,
		5.0000000000e-02,
		6.0000000000e-02,
		7.0000000000e-02,
		8.0000000000e-02,
		9.0000000000e-02,
		1.0000000000e-01,
		1.1000000000e-01,
		1.2000000000e-01,
		1.3000000000e-01,
		1.4000000000e-01,
		1.5000000000e-01,
		1.6000000000e-01,
		1.7000000000e-01,
		1.8000000000e-01,
		1.9000000000e-01,
		2.0000000000e-01,
		2.1000000000e-01,
		2.2000000000e-01,
		2.3000000000e-01,
		2.4000000000e-01,
		2.5000000000e-01,
		2.6000000000e-01,
		2.7000000000e-01,
		2.8000000000e-01,
		2.9000000000e-01,
		3.0000000000e-01,
		3.1000000000e-01,
		3.2000000000e-01,
		3.3000000000e-01,
		3.4000000000e-01,
		3.5000000000e-01,
		3.6000000000e-01,
		3.7000000000e-01,
		3.8000000000e-01,
		3.9000000000e-01,
		4.0000000000e-01,
		4.1000000000e-01,
		4.2000000000e-01,
		4.3000000000e-01,
		4.4000000000e-01,
		4.5000000000e-01,
		4.6000000000e-01,
		4.7000000000e-01,
		4.8000000000e-01,
		4.9000000000e-01,
		5.0000000000e-01,
		5.1000000000e-01,
		5.2000000000e-01,
		5.3000000000e-01,
		5.4000000000e-01,
		5.5000000000e-01,
		5.6000000000e-01,
		5.7000000000e-01,
		5.8000000000e-01,
		5.9000000000e-01,
		6.0000000000e-01,
		6.1000000000e-01,
		6.2000000000e-01,
		6.3000000000e-01,
		6.4000000000e-01,
		6.5000000000e-01,
		6.6000000000e-01,
		6.7000000000e-01,
		6.8000000000e-01,
		6.9000000000e-01,
		7.0000000000e-01,
		7.1000000000e-01,
		7.2000000000e-01,
		7.3000000000e-01,
		7.4000000000e-01,
		7.5000000000e-01,
		7.6000000000e-01,
		7.7000000000e-01,
		7.8000000000e-01,
		7.9000000000e-01,
		8.0000000000e-01,
		8.1000000000e-01,
		8.2000000000e-01,
		8.3000000000e-01,
		8.4000000000e-01,
		8.5000000000e-01,
		8.6000000000e-01,
		8.7000000000e-01,
		8.8000000000e-01,
		8.9000000000e-01,
		9.0000000000e-01,
		9.1000000000e-01,
		9.2000000000e-01,
		9.3000000000e-01,
		9.4000000000e-01,
		9.5000000000e-01,
		9.6000000000e-01,
		9.7000000000e-01,
		9.8000000000e-01,
		9.9000000000e-01,
		1.0000000000e+00,
		1.0100000000e+00,
		1.0200000000e+00,
		1.0300000000e+00,
		1.0400000000e+00,
		1.0500000000e+00,
		1.0600000000e+00,
		1.0700000000e+00,
		1.0800000000e+00,
		1.0900000000e+00,
		1.1000000000e+00,
		1.1100000000e+00,
		1.1200000000e+00,
		1.1300000000e+00,
		1.1400000000e+00,
		1.1500000000e+00,
		1.1600000000e+00,
		1.1700000000e+00,
		1.1800000000e+00,
		1.1900000000e+00,
		1.2000000000e+00
	};

	localparam integer vgs_width_int = 13;
    parameter real vgs_points[0:vgs_width_int-1] =	// Vgs range in volts
	{
		-0.6,
		-0.5,
		-0.4,
		-0.3,
		-0.2,
		-0.1,
		0.0,
		0.1,
		0.2,
		0.3,
		0.4,
		0.5,
		0.6
	};
	localparam integer vgd_width_int = 13;
    parameter real vgd_points[0:vgd_width_int-1] = // Vgd range in volts
	{
		-0.6,
		-0.5,
		-0.4,
		-0.3,
		-0.2,
		-0.1,
		0.0,
		0.1,
		0.2,
		0.3,
		0.4,
		0.5,
		0.6
	};
    // Sample Ids data: Each row corresponds to a fixed Vgs, columns vary Vds
    parameter real table_ids[0 : vds_width_int*vgs_width_int*vgd_width_int-1] =
	{
		//////////////// vgs --> vgd --> vds ////////////////
		2.0207565240e-17
		,1.4589618980e-14
		,2.9197879370e-14
		,4.5137448320e-14
		,6.3969334190e-14
		,8.7323209870e-14
		,1.1728433610e-13
		,1.5529566000e-13
		,2.0536525790e-13
		,2.7186113350e-13
		,3.6073318550e-13
		,4.7987480570e-13
		,6.4001750260e-13
		,8.5566473820e-13
		,1.1465168090e-12
		,1.5391593660e-12
		,2.0697630530e-12
		,2.7873291750e-12
		,3.7585499400e-12
		,5.0738543360e-12
		,6.8562854850e-12
		,9.2731630680e-12
		,1.2551973760e-11
		,1.7002389440e-11
		,2.3045944160e-11
		,3.1256576270e-11
		,4.2415904000e-11
		,5.7589351030e-11
		,7.7941997570e-11
		,1.0461988000e-10
		,1.4067058440e-10
		,1.8944040600e-10
		,2.5548267800e-10
		,3.4499605550e-10
		,4.6642157400e-10
		,6.3125773010e-10
		,8.5517092600e-10
		,1.1595101700e-09
		,1.5612975740e-09
		,2.0771847630e-09
		,2.7640830030e-09
		,3.6787543150e-09
		,4.8967784980e-09
		,6.5187594560e-09
		,8.6785583590e-09
		,1.1554189080e-08
		,1.5382214670e-08
		,2.0476756510e-08
		,2.7254435920e-08
		,3.6267126670e-08
		,4.8244599510e-08
		,6.4149921930e-08
		,8.5251134540e-08
		,1.1321260080e-07
		,1.5016347580e-07
		,1.9885152610e-07
		,2.6299063080e-07
		,3.4725432960e-07
		,4.5759616720e-07
		,6.0152639530e-07
		,7.8841025430e-07
		,1.0297693950e-06
		,1.3395578220e-06
		,1.7343732200e-06
		,2.2335561980e-06
		,2.8591276040e-06
		,3.6355215470e-06
		,4.5890921920e-06
		,5.7468198260e-06
		,7.1368275700e-06
		,8.7862902150e-06
		,1.0720760810e-05
		,1.2963387570e-05
		,1.5534328680e-05
		,1.8450411060e-05
		,2.1725076740e-05
		,2.5368450310e-05
		,2.9387753750e-05
		,3.3787541880e-05
		,3.8570191290e-05
		,4.3736377260e-05
		,4.9285443230e-05
		,5.5215757530e-05
		,6.1525076240e-05
		,6.8210743330e-05
		,7.5269584810e-05
		,8.2698385080e-05
		,9.0493857190e-05
		,9.8652613800e-05
		,1.0717133800e-04
		,1.1604766440e-04
		,1.2527764890e-04
		,1.3485785640e-04
		,1.4478497420e-04
		,1.5505549270e-04
		,1.6524870170e-04
		,1.7570207880e-04
		,1.8646187480e-04
		,1.9752000930e-04
		,2.0886942440e-04
		,2.2050332820e-04
		,2.3241516130e-04
		,2.4459872170e-04
		,2.5704838840e-04
		,2.6975870760e-04
		,2.8272563310e-04
		,2.9594166440e-04
		,3.0940154850e-04
		,3.2310020250e-04
		,3.3703313080e-04
		,3.5119597580e-04
		,3.6558520060e-04
		,3.8019913840e-04
		,3.9503223820e-04
		,4.1008132600e-04
		,4.2534273830e-04
		,4.4059558900e-04
		,4.5462607210e-04
		,4.6879178370e-04
		,4.8305402190e-04
		,4.9740489230e-04
		////////////////////////////////
		,2.9761633090e-18
		,8.2852233920e-15
		,1.4343314360e-14
		,1.9114010740e-14
		,2.3069714030e-14
		,2.6616824230e-14
		,3.0184298800e-14
		,3.4127940110e-14
		,3.8725748090e-14
		,4.4435294800e-14
		,5.1714883300e-14
		,6.1169910180e-14
		,7.3659804680e-14
		,8.9462827820e-14
		,1.1045850780e-13
		,1.3837353560e-13
		,1.7562840100e-13
		,2.2549973330e-13
		,2.9232848820e-13
		,3.8206132710e-13
		,5.0265487570e-13
		,6.6488064020e-13
		,8.8343507440e-13
		,1.1781711550e-12
		,1.5757503000e-12
		,2.1127413030e-12
		,2.8383685350e-12
		,3.8197565580e-12
		,5.1477231630e-12
		,6.9458356710e-12
		,9.3820373840e-12
		,1.2684624530e-11
		,1.7164147980e-11
		,2.3243236920e-11
		,3.1476137330e-11
		,4.2047494280e-11
		,5.6284234150e-11
		,7.5482637010e-11
		,1.0140345080e-10
		,1.3643964360e-10
		,1.8384544360e-10
		,2.4804806190e-10
		,3.3507293360e-10
		,4.5312341650e-10
		,6.1311982970e-10
		,8.1417865960e-10
		,1.0815057710e-09
		,1.4370152310e-09
		,1.9098785430e-09
		,2.5389255670e-09
		,3.3758363600e-09
		,4.4893803340e-09
		,5.9710446590e-09
		,7.9424944550e-09
		,1.0565451210e-08
		,1.4054755820e-08
		,1.8695597950e-08
		,2.4866187220e-08
		,3.3067501620e-08
		,4.3962166080e-08
		,5.8425033200e-08
		,7.7608619040e-08
		,1.0299001490e-07
		,1.3646834250e-07
		,1.8067391350e-07
		,2.3892318990e-07
		,3.1548544220e-07
		,4.1581446170e-07
		,5.4681372400e-07
		,7.1712750760e-07
		,9.3744283450e-07
		,1.2207776140e-06
		,1.5827195130e-06
		,2.0415710840e-06
		,2.6183518630e-06
		,3.3366112110e-06
		,4.2220215800e-06
		,5.3017535470e-06
		,6.6036534410e-06
		,8.1553222440e-06
		,9.9831712120e-06
		,1.2111566630e-05
		,1.4562172800e-05
		,1.7353516800e-05
		,2.0500828960e-05
		,2.4016100650e-05
		,2.7908326370e-05
		,3.2183866880e-05
		,3.6846880250e-05
		,4.1899743670e-05
		,4.7343498680e-05
		,5.3178427130e-05
		,5.9403836640e-05
		,6.6018771400e-05
		,7.3022118730e-05
		,8.0412765500e-05
		,8.8189723490e-05
		,9.6352198970e-05
		,1.0489992470e-04
		,1.1383341290e-04
		,1.2315241520e-04
		,1.3285735030e-04
		,1.4285952730e-04
		,1.5274629730e-04
		,1.6296688210e-04
		,1.7351381350e-04
		,1.8437964510e-04
		,1.9555726380e-04
		,2.0704050020e-04
		,2.1882281520e-04
		,2.3089676560e-04
		,2.4325605640e-04
		,2.5589406850e-04
		,2.6880456760e-04
		,2.8198135690e-04
		,2.9541839450e-04
		,3.0910974110e-04
		,3.2305240460e-04
		,3.3723882580e-04
		,3.5166375410e-04
		,3.6632346890e-04
		////////////////////////////////
		,-1.8954711870e-17
		,8.9612165110e-15
		,1.5272086930e-14
		,1.9753452400e-14
		,2.2979745230e-14
		,2.5321910480e-14
		,2.7146663730e-14
		,2.8625170230e-14
		,2.9900189540e-14
		,3.1026496630e-14
		,3.2160792820e-14
		,3.3397641970e-14
		,3.4815055320e-14
		,3.6509633150e-14
		,3.8549570060e-14
		,4.1137935500e-14
		,4.4510799670e-14
		,4.8895251560e-14
		,5.4545219390e-14
		,6.1616621230e-14
		,7.0944501250e-14
		,8.3170911950e-14
		,9.9396887680e-14
		,1.2092089290e-13
		,1.4967905840e-13
		,1.8799125300e-13
		,2.3926590030e-13
		,3.0796186040e-13
		,4.0006772440e-13
		,5.2374089010e-13
		,6.9007550850e-13
		,9.1389914870e-13
		,1.2153797050e-12
		,1.6218055030e-12
		,2.1702008220e-12
		,2.9106297770e-12
		,3.9111583890e-12
		,5.2640701630e-12
		,7.0947735180e-12
		,9.5735199280e-12
		,1.2931984550e-11
		,1.7237478610e-11
		,2.2951040280e-11
		,3.0627252000e-11
		,4.0955256440e-11
		,5.4869758130e-11
		,7.3639399220e-11
		,9.8987655160e-11
		,1.3325630710e-10
		,1.7962952220e-10
		,2.4243801170e-10
		,3.2332501460e-10
		,4.2851697440e-10
		,5.6815715750e-10
		,7.5357913060e-10
		,9.9985634230e-10
		,1.3270376640e-09
		,1.7617899990e-09
		,2.3395820330e-09
		,3.1075858890e-09
		,4.1285297600e-09
		,5.4858105670e-09
		,7.2902713440e-09
		,9.6891747830e-09
		,1.2878068850e-08
		,1.7116447050e-08
		,2.2748373420e-08
		,3.0229573060e-08
		,4.0162902690e-08
		,5.3344614440e-08
		,7.0795195950e-08
		,9.3814632470e-08
		,1.2425558890e-07
		,1.6444840530e-07
		,2.1741672810e-07
		,2.8706060220e-07
		,3.7837475510e-07
		,4.9770148190e-07
		,6.5301291780e-07
		,8.5421061660e-07
		,1.1134215260e-06
		,1.4452592570e-06
		,1.8670089220e-06
		,2.3986883270e-06
		,3.0629367050e-06
		,3.8846949760e-06
		,4.8906629120e-06
		,6.1085541810e-06
		,7.5662108320e-06
		,9.2906592870e-06
		,1.1307218930e-05
		,1.3638768070e-05
		,1.6305224550e-05
		,1.9323277800e-05
		,2.2706360300e-05
		,2.6464817930e-05
		,3.0606219950e-05
		,3.5135766000e-05
		,4.0056707760e-05
		,4.5370858960e-05
		,5.1078806130e-05
		,5.7180376130e-05
		,6.3674757290e-05
		,7.0560896490e-05
		,7.7837619960e-05
		,8.5503735040e-05
		,9.3558255460e-05
		,1.0200017040e-04
		,1.1082864950e-04
		,1.2004308080e-04
		,1.2960750220e-04
		,1.3910143570e-04
		,1.4895124840e-04
		,1.5915065430e-04
		,1.6969422980e-04
		,1.8057699080e-04
		,1.9179433090e-04
		,2.0334198970e-04
		,2.1521604300e-04
		,2.2741291080e-04
		,2.3992937970e-04
		////////////////////////////////
		,-1.5247349640e-17
		,1.0309234310e-14
		,1.7498958440e-14
		,2.2521337720e-14
		,2.6098315680e-14
		,2.8640730710e-14
		,3.0529292360e-14
		,3.1886552450e-14
		,3.2969937680e-14
		,3.3829575770e-14
		,3.4546454310e-14
		,3.5156550370e-14
		,3.5720696030e-14
		,3.6258681280e-14
		,3.6860109430e-14
		,3.7423471840e-14
		,3.8045525450e-14
		,3.8789399850e-14
		,3.9618282490e-14
		,4.0567576090e-14
		,4.1693935400e-14
		,4.3106127110e-14
		,4.4839136200e-14
		,4.7065433330e-14
		,4.9937385860e-14
		,5.3329517870e-14
		,5.7687913800e-14
		,6.3358872610e-14
		,7.0715584690e-14
		,8.0440048040e-14
		,9.3228985690e-14
		,1.1015915140e-13
		,1.3258373230e-13
		,1.6238460650e-13
		,2.0218246130e-13
		,2.5528332380e-13
		,3.2635888830e-13
		,4.2153497040e-13
		,5.4926143180e-13
		,7.2084562290e-13
		,9.5152036410e-13
		,1.2619878790e-12
		,1.6801258620e-12
		,2.2439901240e-12
		,3.0048552600e-12
		,4.0323230280e-12
		,5.4210196720e-12
		,7.2143232090e-12
		,9.5425529580e-12
		,1.2657333960e-11
		,1.6831522130e-11
		,2.2434403270e-11
		,2.9965963270e-11
		,4.0104127160e-11
		,5.3768184580e-11
		,7.2206255110e-11
		,9.7113348160e-11
		,1.3003592900e-10
		,1.7187811230e-10
		,2.2730183560e-10
		,3.0074330150e-10
		,3.9809481810e-10
		,5.2718389310e-10
		,6.9841047660e-10
		,9.2559425060e-10
		,1.2271008000e-09
		,1.6273381330e-09
		,2.1587457900e-09
		,2.8644352810e-09
		,3.8016957190e-09
		,5.0466446640e-09
		,6.7003920250e-09
		,8.8972017460e-09
		,1.1815274120e-08
		,1.5691035790e-08
		,2.0837902720e-08
		,2.7671009890e-08
		,3.6739651220e-08
		,4.8746853440e-08
		,6.4573973840e-08
		,8.5522004840e-08
		,1.1321617400e-07
		,1.4977757990e-07
		,1.9796199590e-07
		,2.6133022720e-07
		,3.4445295990e-07
		,4.5315076920e-07
		,5.9476597400e-07
		,7.7845713820e-07
		,1.0154987740e-06
		,1.3195590310e-06
		,1.7069178530e-06
		,2.1965798760e-06
		,2.8102335990e-06
		,3.5720148490e-06
		,4.5080513730e-06
		,5.6457955340e-06
		,7.0131932520e-06
		,8.6377552350e-06
		,1.0545645390e-05
		,1.2760886270e-05
		,1.5304754440e-05
		,1.8195417130e-05
		,2.1447811980e-05
		,2.5073740480e-05
		,2.9082124540e-05
		,3.3479388850e-05
		,3.8269846730e-05
		,4.3456093600e-05
		,4.9039439130e-05
		,5.5020254860e-05
		,6.1398269440e-05
		,6.8172944740e-05
		,7.5343461000e-05
		,8.2908668920e-05
		,9.0867689030e-05
		,9.9219545050e-05
		,1.0796347610e-04
		,1.1709881660e-04
		,1.2614226310e-04
		,1.3554588850e-04
		////////////////////////////////
		,5.9002799960e-18
		,1.1715943300e-14
		,1.9883993330e-14
		,2.5607795100e-14
		,2.9649342100e-14
		,3.2532312290e-14
		,3.4632141370e-14
		,3.6226724860e-14
		,3.7374858400e-14
		,3.8350260180e-14
		,3.9089852840e-14
		,3.9775036040e-14
		,4.0354637740e-14
		,4.0881761990e-14
		,4.1383561300e-14
		,4.1847294880e-14
		,4.2317764360e-14
		,4.2792515600e-14
		,4.3280059840e-14
		,4.3737475230e-14
		,4.4285799330e-14
		,4.4795587750e-14
		,4.5382604170e-14
		,4.5996094300e-14
		,4.6626554740e-14
		,4.7326932900e-14
		,4.8153831330e-14
		,4.9073466030e-14
		,5.0209172070e-14
		,5.1558181970e-14
		,5.3196052830e-14
		,5.5040700520e-14
		,5.7307413120e-14
		,6.0158426890e-14
		,6.3835346980e-14
		,6.8461821750e-14
		,7.4441431520e-14
		,8.2263443670e-14
		,9.2466365610e-14
		,1.0585887230e-13
		,1.2359640750e-13
		,1.4704818880e-13
		,1.7823697410e-13
		,2.1967682480e-13
		,2.7500602100e-13
		,3.4898027280e-13
		,4.4799958410e-13
		,5.8074351640e-13
		,7.5890566460e-13
		,9.9836800310e-13
		,1.3204749130e-12
		,1.7540298300e-12
		,2.3384424350e-12
		,3.1025263970e-12
		,4.0675068880e-12
		,5.3523822460e-12
		,7.0667064360e-12
		,9.3582130390e-12
		,1.2426436050e-11
		,1.6541432840e-11
		,2.2068481350e-11
		,2.9501143130e-11
		,3.9511105690e-11
		,5.3008186340e-11
		,6.9928946140e-11
		,9.2196140740e-11
		,1.2162885320e-10
		,1.6055168440e-10
		,2.1204719450e-10
		,2.8020405620e-10
		,3.7044771920e-10
		,4.8997868150e-10
		,6.4835508130e-10
		,8.5826668280e-10
		,1.1365633010e-09
		,1.5056202500e-09
		,1.9951511540e-09
		,2.6446164610e-09
		,3.5064194510e-09
		,4.6501416460e-09
		,6.1681596920e-09
		,8.1830774670e-09
		,1.0857538160e-08
		,1.4407328960e-08
		,1.9118461390e-08
		,2.5369833870e-08
		,3.3645264550e-08
		,4.4536434840e-08
		,5.8956809780e-08
		,7.8034252230e-08
		,1.0324693510e-07
		,1.3652552350e-07
		,1.8038121440e-07
		,2.3806381610e-07
		,3.1375331570e-07
		,4.1278659890e-07
		,5.4191771810e-07
		,7.0960492920e-07
		,9.2631039600e-07
		,1.2047892000e-06
		,1.5603337570e-06
		,2.0109320330e-06
		,2.5772897100e-06
		,3.2826726150e-06
		,4.1525380780e-06
		,5.2139504080e-06
		,6.4948100050e-06
		,8.0229599950e-06
		,9.8252706410e-06
		,1.1926794060e-05
		,1.4350086740e-05
		,1.7114770560e-05
		,2.0237297410e-05
		,2.3730961700e-05
		,2.7606099140e-05
		,3.1870409220e-05
		,3.6529347900e-05
		,4.1586552040e-05
		,4.7044178530e-05
		,5.2903327840e-05
		,5.9164331700e-05
		////////////////////////////////
		,1.3628302680e-17
		,1.3338828060e-14
		,2.2663105160e-14
		,2.9151928960e-14
		,3.3776001780e-14
		,3.7086101870e-14
		,3.9486122860e-14
		,4.1278658610e-14
		,4.2658685040e-14
		,4.3722541350e-14
		,4.4624840220e-14
		,4.5354511760e-14
		,4.6066429750e-14
		,4.6667753460e-14
		,4.7190700400e-14
		,4.7751138690e-14
		,4.8298052940e-14
		,4.8778809060e-14
		,4.9284420160e-14
		,4.9826008350e-14
		,5.0290525170e-14
		,5.0802819970e-14
		,5.1323417180e-14
		,5.1840724750e-14
		,5.2367640130e-14
		,5.2880979260e-14
		,5.3394005090e-14
		,5.3951153750e-14
		,5.4515299410e-14
		,5.5067800810e-14
		,5.5664163970e-14
		,5.6281413670e-14
		,5.6961584100e-14
		,5.7685511850e-14
		,5.8491053780e-14
		,5.9403743700e-14
		,6.0425722490e-14
		,6.1595003650e-14
		,6.2909655180e-14
		,6.4468574890e-14
		,6.6389615130e-14
		,6.8832505760e-14
		,7.1754063850e-14
		,7.5573586840e-14
		,8.0446783950e-14
		,8.6710816290e-14
		,9.4887899750e-14
		,1.0559559730e-13
		,1.1969683680e-13
		,1.3828006830e-13
		,1.6286645920e-13
		,1.9549954920e-13
		,2.3898199990e-13
		,2.9697062790e-13
		,3.7445695280e-13
		,4.7824915350e-13
		,6.1733006440e-13
		,8.0404943130e-13
		,1.0548589610e-12
		,1.3888218060e-12
		,1.7962605500e-12
		,2.3359981860e-12
		,3.0525421200e-12
		,4.0058574750e-12
		,5.2768717890e-12
		,6.9744326970e-12
		,9.2458233080e-12
		,1.2289936510e-11
		,1.6376094980e-11
		,2.1867701050e-11
		,2.8932803500e-11
		,3.8003698690e-11
		,4.9960638560e-11
		,6.5730338360e-11
		,8.6539614440e-11
		,1.1401256780e-10
		,1.5030040780e-10
		,1.9825292750e-10
		,2.6164700700e-10
		,3.4548920690e-10
		,4.5641771590e-10
		,6.0322055860e-10
		,7.9757909790e-10
		,1.0549840780e-09
		,1.3959866330e-09
		,1.8478572350e-09
		,2.4467854930e-09
		,3.2407918390e-09
		,4.2935971120e-09
		,5.6897739710e-09
		,7.5415175990e-09
		,9.9976544530e-09
		,1.3255554000e-08
		,1.7576888370e-08
		,2.3294838040e-08
		,3.0802166790e-08
		,4.0741873870e-08
		,5.3894433060e-08
		,7.1285725130e-08
		,9.4260706270e-08
		,1.2457715200e-07
		,1.6452354350e-07
		,2.1706541440e-07
		,2.8602395020e-07
		,3.7628927370e-07
		,4.9406823180e-07
		,6.4716112090e-07
		,8.4526048320e-07
		,1.1002447900e-06
		,1.4264439510e-06
		,1.8408344420e-06
		,2.3631181030e-06
		,3.0156379370e-06
		,3.8230937840e-06
		,4.8120422070e-06
		,6.0101971770e-06
		,7.4455833020e-06
		,9.1456270510e-06
		,1.1136283080e-05
		,1.3441292400e-05
		,1.6081642330e-05
		////////////////////////////////
		,-1.0965607350e-17
		,1.5153555770e-14
		,2.5732644440e-14
		,3.3177080020e-14
		,3.8464091860e-14
		,4.2221216300e-14
		,4.4985237600e-14
		,4.7033424690e-14
		,4.8603518710e-14
		,4.9844806240e-14
		,5.0870231300e-14
		,5.1710183820e-14
		,5.2383774990e-14
		,5.3098982600e-14
		,5.3669028710e-14
		,5.4280377960e-14
		,5.4824368100e-14
		,5.5311703480e-14
		,5.5857416750e-14
		,5.6367727330e-14
		,5.6874487200e-14
		,5.7373675690e-14
		,5.7865449460e-14
		,5.8345056810e-14
		,5.8863826440e-14
		,5.9346044620e-14
		,5.9835312000e-14
		,6.0304371640e-14
		,6.0807633010e-14
		,6.1316690400e-14
		,6.1804077990e-14
		,6.2270422390e-14
		,6.2816292310e-14
		,6.3320023630e-14
		,6.3825739170e-14
		,6.4340905870e-14
		,6.4912466250e-14
		,6.5476194180e-14
		,6.6028538930e-14
		,6.6677901700e-14
		,6.7341362890e-14
		,6.8023621980e-14
		,6.8807494120e-14
		,6.9625359110e-14
		,7.0543897270e-14
		,7.1570418870e-14
		,7.2767949090e-14
		,7.4147035630e-14
		,7.5801302430e-14
		,7.7886458710e-14
		,8.0431902290e-14
		,8.3618040720e-14
		,8.7647682390e-14
		,9.2803892220e-14
		,9.9482992480e-14
		,1.0815409500e-13
		,1.1947460390e-13
		,1.3438890440e-13
		,1.5402037960e-13
		,1.8007368490e-13
		,2.1464462890e-13
		,2.6068307080e-13
		,3.2215975230e-13
		,4.0428638930e-13
		,5.1436032370e-13
		,6.6201114190e-13
		,8.4011841070e-13
		,1.0714308180e-12
		,1.3768417520e-12
		,1.7811134170e-12
		,2.3175190220e-12
		,3.0308003210e-12
		,3.9812653400e-12
		,5.2503014370e-12
		,6.9477026150e-12
		,9.2218646100e-12
		,1.2222140700e-11
		,1.5975769670e-11
		,2.0908119050e-11
		,2.7393303480e-11
		,3.5925746280e-11
		,4.7158045600e-11
		,6.1953001700e-11
		,8.1451058110e-11
		,1.0716070300e-10
		,1.4107752150e-10
		,1.8584269050e-10
		,2.4495270920e-10
		,3.2303205990e-10
		,4.2620744810e-10
		,5.6260916530e-10
		,7.4300349020e-10
		,9.8166044370e-10
		,1.2975017280e-09
		,1.7156154860e-09
		,2.2692720630e-09
		,3.0025965370e-09
		,3.9741132870e-09
		,5.2614481820e-09
		,6.9675636500e-09
		,9.2290284980e-09
		,1.2226907020e-08
		,1.6191105600e-08
		,2.1378698420e-08
		,2.8244566010e-08
		,3.7328144420e-08
		,4.9339866500e-08
		,6.5213543780e-08
		,8.6173699960e-08
		,1.1382129910e-07
		,1.5024245680e-07
		,1.9814349230e-07
		,2.6101694580e-07
		,3.4334152770e-07
		,4.5081686470e-07
		,5.9063032990e-07
		,7.7174754280e-07
		,1.0052103110e-06
		,1.3044163110e-06
		,1.6853447380e-06
		,2.1666839280e-06
		////////////////////////////////
		,-5.4306721840e-17
		,1.6760410110e-14
		,2.8558072190e-14
		,3.6905067720e-14
		,4.2869221440e-14
		,4.7140781550e-14
		,5.0255070260e-14
		,5.2620524010e-14
		,5.4364968480e-14
		,5.5750425410e-14
		,5.6841173150e-14
		,5.7770990050e-14
		,5.8572981270e-14
		,5.9224850420e-14
		,5.9876667360e-14
		,6.0485196930e-14
		,6.1048715990e-14
		,6.1595578030e-14
		,6.2114086580e-14
		,6.2671757400e-14
		,6.3136691960e-14
		,6.3650501030e-14
		,6.4208641810e-14
		,6.4718482440e-14
		,6.5202893700e-14
		,6.5704327490e-14
		,6.6219755280e-14
		,6.6722703350e-14
		,6.7257868920e-14
		,6.7769014960e-14
		,6.8265435980e-14
		,6.8807650760e-14
		,6.9341719790e-14
		,6.9870880480e-14
		,7.0370121190e-14
		,7.0925076760e-14
		,7.1435387340e-14
		,7.2011438330e-14
		,7.2570153480e-14
		,7.3087252190e-14
		,7.3701682210e-14
		,7.4241025090e-14
		,7.4833263150e-14
		,7.5433803620e-14
		,7.6026877140e-14
		,7.6652011520e-14
		,7.7316255960e-14
		,7.7990525930e-14
		,7.8703279380e-14
		,7.9394885190e-14
		,8.0193691210e-14
		,8.1024662520e-14
		,8.1958656720e-14
		,8.2954683960e-14
		,8.4111380980e-14
		,8.5407913440e-14
		,8.6956494310e-14
		,8.8834978200e-14
		,9.1054278330e-14
		,9.3800076120e-14
		,9.7247296400e-14
		,1.0159404810e-13
		,1.0715326390e-13
		,1.1431844630e-13
		,1.2364851940e-13
		,1.3577817320e-13
		,1.5170427030e-13
		,1.7282077900e-13
		,2.0068839430e-13
		,2.3765481640e-13
		,2.8702215630e-13
		,3.5273656180e-13
		,4.3355773730e-13
		,5.3489039040e-13
		,6.6785493690e-13
		,8.4290008110e-13
		,1.0739024800e-12
		,1.3796614890e-12
		,1.7852565770e-12
		,2.3245886490e-12
		,3.0431824930e-12
		,4.0026766100e-12
		,5.2845325570e-12
		,6.8807674950e-12
		,8.9498474020e-12
		,1.1661447120e-11
		,1.5217552580e-11
		,1.9884365430e-11
		,2.6012759900e-11
		,3.4065553620e-11
		,4.4653425090e-11
		,5.8582385970e-11
		,7.6917023910e-11
		,1.0105480400e-10
		,1.3284652220e-10
		,1.7475320560e-10
		,2.3001939600e-10
		,3.0293750150e-10
		,3.9918793850e-10
		,5.2628991270e-10
		,6.9419961120e-10
		,9.1610296920e-10
		,1.2094683830e-09
		,1.5974416000e-09
		,2.1106978330e-09
		,2.7898988680e-09
		,3.6889540300e-09
		,4.8793273170e-09
		,6.4557584500e-09
		,8.5440895190e-09
		,1.1303676800e-08
		,1.4899342080e-08
		,1.9655242630e-08
		,2.5944277900e-08
		,3.4258140530e-08
		,4.5244208990e-08
		,5.9753327470e-08
		,7.8901325000e-08
		,1.0414764980e-07
		,1.3739497230e-07
		,1.8111392960e-07
		////////////////////////////////
		,1.2949489870e-17
		,1.7868493680e-14
		,3.0488720240e-14
		,3.9482258850e-14
		,4.5935993250e-14
		,5.0619958250e-14
		,5.4075219850e-14
		,5.6700136740e-14
		,5.8773022180e-14
		,6.0376482450e-14
		,6.1734421360e-14
		,6.2864749110e-14
		,6.3867460050e-14
		,6.4744172890e-14
		,6.5550080340e-14
		,6.6295573450e-14
		,6.7001382110e-14
		,6.7656906410e-14
		,6.8327521250e-14
		,6.8922004610e-14
		,6.9513041700e-14
		,7.0081677960e-14
		,7.0663368320e-14
		,7.1286257390e-14
		,7.1836670140e-14
		,7.2402330070e-14
		,7.2993053860e-14
		,7.3553439940e-14
		,7.4126410160e-14
		,7.4710867980e-14
		,7.5266502370e-14
		,7.5834825340e-14
		,7.6424713660e-14
		,7.7007396130e-14
		,7.7626055680e-14
		,7.8193334310e-14
		,7.8776382300e-14
		,7.9369194740e-14
		,7.9962059400e-14
		,8.0571058910e-14
		,8.1193478040e-14
		,8.1828637960e-14
		,8.2424844460e-14
		,8.3062093040e-14
		,8.3672867910e-14
		,8.4333874930e-14
		,8.4968356040e-14
		,8.5630459600e-14
		,8.6238258140e-14
		,8.6918010840e-14
		,8.7620790960e-14
		,8.8288533890e-14
		,8.8971628440e-14
		,8.9730227850e-14
		,9.0428256280e-14
		,9.1174167120e-14
		,9.1973651950e-14
		,9.2752615750e-14
		,9.3600870670e-14
		,9.4470429870e-14
		,9.5455961630e-14
		,9.6513551980e-14
		,9.7608894760e-14
		,9.8949341180e-14
		,1.0042711670e-13
		,1.0210367980e-13
		,1.0417233580e-13
		,1.0664702620e-13
		,1.0967802980e-13
		,1.1344956590e-13
		,1.1820172550e-13
		,1.2433704450e-13
		,1.3214213850e-13
		,1.4223864350e-13
		,1.5544792290e-13
		,1.7277331430e-13
		,1.9562518180e-13
		,2.2587877190e-13
		,2.6381004810e-13
		,3.0946214110e-13
		,3.6877001570e-13
		,4.4626589620e-13
		,5.4792662470e-13
		,6.8156345700e-13
		,8.5807697780e-13
		,1.0919025070e-12
		,1.4025980510e-12
		,1.8157649830e-12
		,2.3653518800e-12
		,3.0677545240e-12
		,3.9511429170e-12
		,5.1048016720e-12
		,6.6125904350e-12
		,8.5847307040e-12
		,1.1165982650e-11
		,1.4546891640e-11
		,1.8978290020e-11
		,2.4790222110e-11
		,3.2416400580e-11
		,4.2419996510e-11
		,5.5561870340e-11
		,7.2836653210e-11
		,9.5556772130e-11
		,1.2545494510e-10
		,1.6481939580e-10
		,2.1667322010e-10
		,2.8501195760e-10
		,3.7511828460e-10
		,4.9397882270e-10
		,6.5083676460e-10
		,8.5786496770e-10
		,1.1312463920e-09
		,1.4924150270e-09
		,1.9697570130e-09
		,2.6008737460e-09
		,3.4356082880e-09
		,4.5400625250e-09
		,6.0019512660e-09
		,7.9323311260e-09
		,1.0433777650e-08
		,1.3739490640e-08
		////////////////////////////////
		,-2.5587718630e-17
		,1.8615501060e-14
		,3.1809167790e-14
		,4.1221272820e-14
		,4.8030757350e-14
		,5.3019613720e-14
		,5.6768018020e-14
		,5.9613757940e-14
		,6.1881149350e-14
		,6.3722872920e-14
		,6.5297979710e-14
		,6.6665421990e-14
		,6.7880026960e-14
		,6.8979024890e-14
		,7.0025440930e-14
		,7.1027890800e-14
		,7.1957968770e-14
		,7.2890239830e-14
		,7.3772017660e-14
		,7.4617505120e-14
		,7.5434221350e-14
		,7.6242374100e-14
		,7.7065512950e-14
		,7.7847139780e-14
		,7.8554410510e-14
		,7.9325594070e-14
		,8.0017565400e-14
		,8.0711103220e-14
		,8.1448137270e-14
		,8.2135461340e-14
		,8.2796207280e-14
		,8.3463532490e-14
		,8.4120309980e-14
		,8.4810036000e-14
		,8.5473706060e-14
		,8.6150639070e-14
		,8.6794571340e-14
		,8.7488213600e-14
		,8.8138202960e-14
		,8.8826780230e-14
		,8.9516715120e-14
		,9.0210148500e-14
		,9.0847031560e-14
		,9.1594038940e-14
		,9.2275044830e-14
		,9.2997667170e-14
		,9.3708749690e-14
		,9.4403697350e-14
		,9.5143028930e-14
		,9.5864084770e-14
		,9.6590988850e-14
		,9.7312775730e-14
		,9.8063333820e-14
		,9.8801464420e-14
		,9.9560324920e-14
		,1.0030362490e-13
		,1.0106838590e-13
		,1.0184729750e-13
		,1.0262171840e-13
		,1.0338820250e-13
		,1.0425222680e-13
		,1.0505364360e-13
		,1.0589484940e-13
		,1.0673965800e-13
		,1.0760227240e-13
		,1.0851229930e-13
		,1.0942295280e-13
		,1.1043986660e-13
		,1.1146429950e-13
		,1.1255870240e-13
		,1.1373858350e-13
		,1.1504566370e-13
		,1.1655189710e-13
		,1.1811755270e-13
		,1.2008992160e-13
		,1.2236117700e-13
		,1.2511961120e-13
		,1.2848010010e-13
		,1.3260498440e-13
		,1.3785032760e-13
		,1.4453376180e-13
		,1.5310037940e-13
		,1.6430731770e-13
		,1.7897353820e-13
		,1.9784500410e-13
		,2.1960607170e-13
		,2.4702859460e-13
		,2.8244868120e-13
		,3.2846002280e-13
		,3.8834447060e-13
		,4.6667403760e-13
		,5.6945694810e-13
		,7.0503513280e-13
		,8.8453788410e-13
		,1.1229642500e-12
		,1.4376877650e-12
		,1.8233301430e-12
		,2.3251082540e-12
		,2.9786580460e-12
		,3.8305013820e-12
		,4.9417682250e-12
		,6.3897347820e-12
		,8.2752945670e-12
		,1.0738422020e-11
		,1.3959657110e-11
		,1.8175476340e-11
		,2.3696532710e-11
		,3.0931684720e-11
		,4.0419360040e-11
		,5.2868309860e-11
		,6.9212476460e-11
		,9.0682937930e-11
		,1.1890323700e-10
		,1.5601522000e-10
		,2.0484587140e-10
		,2.6909793340e-10
		,3.5369405560e-10
		,4.6515438700e-10
		,6.1208026770e-10
		,8.0584630750e-10
		,1.0615014050e-09
		////////////////////////////////
		,1.1591864270e-17
		,1.9179176770e-14
		,3.2805038390e-14
		,4.2548351850e-14
		,4.9608788250e-14
		,5.4777007850e-14
		,5.8717933910e-14
		,6.1759433000e-14
		,6.4215482150e-14
		,6.6259805230e-14
		,6.7949944680e-14
		,6.9477900080e-14
		,7.0894791270e-14
		,7.2154981130e-14
		,7.3424935450e-14
		,7.4584138860e-14
		,7.5708722800e-14
		,7.6856751900e-14
		,7.7969012790e-14
		,7.9040127180e-14
		,8.0128316320e-14
		,8.1177917560e-14
		,8.2248875300e-14
		,8.3296805620e-14
		,8.4319358780e-14
		,8.5316900300e-14
		,8.6319820110e-14
		,8.7324880790e-14
		,8.8298246140e-14
		,8.9244511180e-14
		,9.0175894570e-14
		,9.1074694930e-14
		,9.2004094090e-14
		,9.2846239700e-14
		,9.3705094550e-14
		,9.4586924590e-14
		,9.5393667500e-14
		,9.6175137690e-14
		,9.7025167970e-14
		,9.7784341760e-14
		,9.8596776250e-14
		,9.9410672810e-14
		,1.0018222190e-13
		,1.0097089790e-13
		,1.0176907730e-13
		,1.0255780560e-13
		,1.0333457630e-13
		,1.0412283460e-13
		,1.0494419810e-13
		,1.0575558830e-13
		,1.0659898710e-13
		,1.0737852530e-13
		,1.0820401390e-13
		,1.0904229550e-13
		,1.0987592980e-13
		,1.1070648340e-13
		,1.1155740130e-13
		,1.1240403750e-13
		,1.1326529430e-13
		,1.1414566230e-13
		,1.1497444050e-13
		,1.1587694830e-13
		,1.1676728960e-13
		,1.1767548890e-13
		,1.1853016640e-13
		,1.1951893560e-13
		,1.2040562180e-13
		,1.2131899050e-13
		,1.2230447010e-13
		,1.2319893650e-13
		,1.2416415610e-13
		,1.2516420400e-13
		,1.2616581840e-13
		,1.2718915480e-13
		,1.2824173230e-13
		,1.2937164240e-13
		,1.3049319780e-13
		,1.3169359990e-13
		,1.3295692270e-13
		,1.3438906110e-13
		,1.3592432680e-13
		,1.3756172770e-13
		,1.3946689420e-13
		,1.4162849520e-13
		,1.4420772280e-13
		,1.4719904190e-13
		,1.5094770730e-13
		,1.5557773280e-13
		,1.6129923710e-13
		,1.6867949870e-13
		,1.7814695310e-13
		,1.8883987350e-13
		,2.0229900820e-13
		,2.1931689740e-13
		,2.4110610960e-13
		,2.6910473580e-13
		,3.0539516480e-13
		,3.5252962830e-13
		,4.1410693080e-13
		,4.9484800630e-13
		,6.0030016550e-13
		,7.3985901280e-13
		,9.1335244330e-13
		,1.1344458980e-12
		,1.4210189940e-12
		,1.7929517560e-12
		,2.2761838130e-12
		,2.9043690340e-12
		,3.7219126380e-12
		,4.7868810010e-12
		,6.1753938960e-12
		,7.9870511220e-12
		,1.0352515370e-11
		,1.3443396320e-11
		,1.7484839090e-11
		,2.2765913930e-11
		,2.9664739570e-11
		,3.8698845340e-11
		,5.0535322890e-11
		,6.6048781400e-11
		,8.6400123940e-11
		////////////////////////////////
		,-2.9242864500e-18
		,1.9640351750e-14
		,3.3563272290e-14
		,4.3580095100e-14
		,5.0838431540e-14
		,5.6242355830e-14
		,6.0300559850e-14
		,6.3490405640e-14
		,6.6043107300e-14
		,6.8173691820e-14
		,7.0038129510e-14
		,7.1695216000e-14
		,7.3199047440e-14
		,7.4601265820e-14
		,7.5968916970e-14
		,7.7336724770e-14
		,7.8592946190e-14
		,7.9876059040e-14
		,8.1177134310e-14
		,8.2476799750e-14
		,8.3674904350e-14
		,8.4973943190e-14
		,8.6220609010e-14
		,8.7498917950e-14
		,8.8742085280e-14
		,8.9999977620e-14
		,9.1243406020e-14
		,9.2524378000e-14
		,9.3768067490e-14
		,9.4986901980e-14
		,9.6194196660e-14
		,9.7424362110e-14
		,9.8648000510e-14
		,9.9869080310e-14
		,1.0101042570e-13
		,1.0216534740e-13
		,1.0335368750e-13
		,1.0445921250e-13
		,1.0557512850e-13
		,1.0666232560e-13
		,1.0771824500e-13
		,1.0882121130e-13
		,1.0982830850e-13
		,1.1084308140e-13
		,1.1182574120e-13
		,1.1278485150e-13
		,1.1377529160e-13
		,1.1472505520e-13
		,1.1569868160e-13
		,1.1659732530e-13
		,1.1753815990e-13
		,1.1849768790e-13
		,1.1943988000e-13
		,1.2036144670e-13
		,1.2133157470e-13
		,1.2230217250e-13
		,1.2324227610e-13
		,1.2419344940e-13
		,1.2515809460e-13
		,1.2607720720e-13
		,1.2708513980e-13
		,1.2805897510e-13
		,1.2908231150e-13
		,1.3006773880e-13
		,1.3104982430e-13
		,1.3207958330e-13
		,1.3307879570e-13
		,1.3415836920e-13
		,1.3514003690e-13
		,1.3619741840e-13
		,1.3722080700e-13
		,1.3825218480e-13
		,1.3934596100e-13
		,1.4043743980e-13
		,1.4154641110e-13
		,1.4258979860e-13
		,1.4371673230e-13
		,1.4481217950e-13
		,1.4592830440e-13
		,1.4710578350e-13
		,1.4823585020e-13
		,1.4943458140e-13
		,1.5065853310e-13
		,1.5189475560e-13
		,1.5319071370e-13
		,1.5452928030e-13
		,1.5591776580e-13
		,1.5740483580e-13
		,1.5903957370e-13
		,1.6073681450e-13
		,1.6267143100e-13
		,1.6482619170e-13
		,1.6731785240e-13
		,1.7017539330e-13
		,1.7364621530e-13
		,1.7782785890e-13
		,1.8298981250e-13
		,1.8890519610e-13
		,1.9594772230e-13
		,2.0453903820e-13
		,2.1537628460e-13
		,2.2894241070e-13
		,2.4618644900e-13
		,2.6831710400e-13
		,2.9673675080e-13
		,3.3346830370e-13
		,3.8129682720e-13
		,4.4392430530e-13
		,5.2430138060e-13
		,6.2470139710e-13
		,7.5438075070e-13
		,9.2206004500e-13
		,1.1390694490e-12
		,1.4196227280e-12
		,1.7803055250e-12
		,2.2480892650e-12
		,2.8554295030e-12
		,3.6447598710e-12
		,4.6714021510e-12
		,6.0079504630e-12
		,7.7493211130e-12
		////////////////////////////////
		,5.1170344500e-18
		,2.0031086840e-14
		,3.4250857440e-14
		,4.4487458950e-14
		,5.1947350570e-14
		,5.7435238790e-14
		,6.1636150150e-14
		,6.4938365570e-14
		,6.7552943620e-14
		,6.9829159600e-14
		,7.1757144610e-14
		,7.3485036490e-14
		,7.5107869040e-14
		,7.6643500250e-14
		,7.8124095410e-14
		,7.9535033930e-14
		,8.0954744800e-14
		,8.2358111940e-14
		,8.3749469320e-14
		,8.5128138130e-14
		,8.6551817440e-14
		,8.7995495630e-14
		,8.9411081400e-14
		,9.0794501890e-14
		,9.2230399840e-14
		,9.3658465330e-14
		,9.5126528560e-14
		,9.6558562490e-14
		,9.8025529170e-14
		,9.9459495110e-14
		,1.0093810600e-13
		,1.0241018990e-13
		,1.0386055180e-13
		,1.0529592760e-13
		,1.0676158890e-13
		,1.0822317730e-13
		,1.0967552340e-13
		,1.1115512640e-13
		,1.1260527940e-13
		,1.1405224720e-13
		,1.1547033940e-13
		,1.1691161560e-13
		,1.1829608050e-13
		,1.1971224060e-13
		,1.2107404350e-13
		,1.2242388890e-13
		,1.2375953140e-13
		,1.2510629600e-13
		,1.2637974880e-13
		,1.2764954650e-13
		,1.2889918870e-13
		,1.3008491800e-13
		,1.3132020060e-13
		,1.3250807080e-13
		,1.3364617880e-13
		,1.3480005610e-13
		,1.3594735420e-13
		,1.3707935290e-13
		,1.3816942180e-13
		,1.3930413570e-13
		,1.4040475240e-13
		,1.4156144940e-13
		,1.4269386580e-13
		,1.4382356690e-13
		,1.4492475800e-13
		,1.4608876530e-13
		,1.4722311370e-13
		,1.4835234490e-13
		,1.4952700430e-13
		,1.5067889740e-13
		,1.5187345130e-13
		,1.5303542220e-13
		,1.5424710310e-13
		,1.5540531430e-13
		,1.5664111920e-13
		,1.5785149460e-13
		,1.5909163340e-13
		,1.6028091340e-13
		,1.6154512390e-13
		,1.6278432280e-13
		,1.6406973320e-13
		,1.6527979530e-13
		,1.6660562120e-13
		,1.6790251910e-13
		,1.6920855500e-13
		,1.7048848260e-13
		,1.7184950230e-13
		,1.7321595250e-13
		,1.7456585000e-13
		,1.7598263680e-13
		,1.7736725830e-13
		,1.7882174520e-13
		,1.8032944070e-13
		,1.8183901590e-13
		,1.8341955320e-13
		,1.8510045040e-13
		,1.8682583590e-13
		,1.8870296210e-13
		,1.9073720750e-13
		,1.9290632770e-13
		,1.9541396660e-13
		,1.9828372600e-13
		,2.0150244750e-13
		,2.0526380140e-13
		,2.0945395620e-13
		,2.1439936860e-13
		,2.2042080370e-13
		,2.2767397070e-13
		,2.3665361970e-13
		,2.4783016810e-13
		,2.6187005330e-13
		,2.7951114490e-13
		,3.0212177280e-13
		,3.3110948140e-13
		,3.6866182340e-13
		,4.1485769770e-13
		,4.7402296940e-13
		,5.5003298090e-13
		,6.4785679840e-13
		,7.7385322700e-13
		,9.3656872880e-13
		////////////////////////////////
		,1.1330782430e-17
		,1.0464750470e-13
		,1.8127570570e-13
		,2.3986576190e-13
		,2.8773496200e-13
		,3.3033902890e-13
		,3.7234078000e-13
		,4.1785810250e-13
		,4.7124166450e-13
		,5.3621699940e-13
		,6.1853245080e-13
		,7.2587526020e-13
		,8.6762061580e-13
		,1.0563705210e-12
		,1.3088760900e-12
		,1.6478343190e-12
		,2.1041283690e-12
		,2.7195876260e-12
		,3.5508938450e-12
		,4.6749538560e-12
		,6.1963012260e-12
		,8.2563952170e-12
		,1.1048399010e-11
		,1.4835051330e-11
		,1.9973529690e-11
		,2.6950241110e-11
		,3.6427390510e-11
		,4.9307235600e-11
		,6.6819064750e-11
		,9.0638877860e-11
		,1.2293975160e-10
		,1.6510222570e-10
		,2.2212977830e-10
		,2.9934248620e-10
		,4.0398215910e-10
		,5.4591042710e-10
		,7.3855901920e-10
		,1.0002280590e-09
		,1.3558412730e-09
		,1.8393018340e-09
		,2.4848077130e-09
		,3.3070109080e-09
		,4.4020242130e-09
		,5.8603082220e-09
		,7.8024954930e-09
		,1.0388974470e-08
		,1.3832753230e-08
		,1.8417355430e-08
		,2.4518839890e-08
		,3.2635728270e-08
		,4.3427835460e-08
		,5.7766632180e-08
		,7.6801169050e-08
		,1.0204133690e-07
		,1.3546454210e-07
		,1.7960685570e-07
		,2.3771226920e-07
		,3.1414777020e-07
		,4.1438631340e-07
		,5.4535778020e-07
		,7.1574113280e-07
		,9.3626661310e-07
		,1.2200039020e-06
		,1.5825983090e-06
		,2.0424110450e-06
		,2.6205113100e-06
		,3.3404768880e-06
		,4.2279681130e-06
		,5.3100725160e-06
		,6.6144590480e-06
		,8.1684356450e-06
		,9.9979626390e-06
		,1.2126791860e-05
		,1.4575823930e-05
		,1.7362613930e-05
		,2.0501300020e-05
		,2.4002650390e-05
		,2.7874159220e-05
		,3.2120788650e-05
		,3.6745023320e-05
		,4.1745925580e-05
		,4.7120702210e-05
		,5.2869022210e-05
		,5.8987792390e-05
		,6.5473287880e-05
		,7.2321383280e-05
		,7.9527692920e-05
		,8.7087721110e-05
		,9.4996843600e-05
		,1.0325030610e-04
		,1.1184336580e-04
		,1.2077143660e-04
		,1.3002964070e-04
		,1.3961287180e-04
		,1.4951636770e-04
		,1.5973508710e-04
		,1.7008445510e-04
		,1.8046046890e-04
		,1.9111502730e-04
		,2.0204120880e-04
		,2.1323036120e-04
		,2.2467436780e-04
		,2.3636587490e-04
		,2.4829854810e-04
		,2.6046524410e-04
		,2.7283672140e-04
		,2.8538174910e-04
		,2.9813460380e-04
		,3.1108934580e-04
		,3.2424407360e-04
		,3.3759267440e-04
		,3.5112885040e-04
		,3.6484781760e-04
		,3.7874494340e-04
		,3.9281929960e-04
		,4.0706746320e-04
		,4.2148403640e-04
		,4.3606667960e-04
		,4.5081749790e-04
		,4.6572775070e-04
		,4.7982019130e-04
		////////////////////////////////
		,1.3732735420e-17
		,1.1178140950e-13
		,1.8984216670e-13
		,2.4487273740e-13
		,2.8420153250e-13
		,3.1281787830e-13
		,3.3432794180e-13
		,3.5123528890e-13
		,3.6530744390e-13
		,3.7795320420e-13
		,3.9037657510e-13
		,4.0355588230e-13
		,4.1849012950e-13
		,4.3633570030e-13
		,4.5841372120e-13
		,4.8587117700e-13
		,5.2077996080e-13
		,5.6621102200e-13
		,6.2585694540e-13
		,7.0475118020e-13
		,8.0961042240e-13
		,9.4960282230e-13
		,1.1369877390e-12
		,1.3884827130e-12
		,1.7266750840e-12
		,2.1822554930e-12
		,2.7968205440e-12
		,3.6265460180e-12
		,4.7481479430e-12
		,6.2657251340e-12
		,8.3206276180e-12
		,1.1105160080e-11
		,1.4880805450e-11
		,2.0003460630e-11
		,2.6957546020e-11
		,3.6402935800e-11
		,4.9238529720e-11
		,6.5923888310e-11
		,8.8272569380e-11
		,1.1845313930e-10
		,1.5925643380e-10
		,2.1447864520e-10
		,2.8928585440e-10
		,3.9071073810e-10
		,5.2833025510e-10
		,7.1518952210e-10
		,9.6906053270e-10
		,1.2911818170e-09
		,1.7166197620e-09
		,2.2828021450e-09
		,3.0363688230e-09
		,4.0394237280e-09
		,5.3746266600e-09
		,7.1519628220e-09
		,9.5176984340e-09
		,1.2666253510e-08
		,1.6855864090e-08
		,2.2429221610e-08
		,2.9840582840e-08
		,3.9691250960e-08
		,5.2775806060e-08
		,7.0142012920e-08
		,9.3167935820e-08
		,1.2362771550e-07
		,1.6378118270e-07
		,2.1674844120e-07
		,2.8645306000e-07
		,3.7792208160e-07
		,4.9754083480e-07
		,6.5333705350e-07
		,8.5528205520e-07
		,1.1155874930e-06
		,1.4489660290e-06
		,1.8728141450e-06
		,2.4072680990e-06
		,3.0750842820e-06
		,3.9013073770e-06
		,4.9127120820e-06
		,6.1370422290e-06
		,7.6021061480e-06
		,9.3348178320e-06
		,1.1360304340e-05
		,1.3701169110e-05
		,1.6376984970e-05
		,1.9404044880e-05
		,2.2795357540e-05
		,2.6560853570e-05
		,3.0707705130e-05
		,3.5238843850e-05
		,4.0150807330e-05
		,4.5449010290e-05
		,5.1132757280e-05
		,5.7200523360e-05
		,6.3650247140e-05
		,7.0479208690e-05
		,7.7684560480e-05
		,8.5263419020e-05
		,9.3212959740e-05
		,1.0153030690e-04
		,1.1021215500e-04
		,1.1925546330e-04
		,1.2865742630e-04
		,1.3841582930e-04
		,1.4852687150e-04
		,1.5856384630e-04
		,1.6887076880e-04
		,1.7949179830e-04
		,1.9041964020e-04
		,2.0164692730e-04
		,2.1316784730e-04
		,2.2497535590e-04
		,2.3706235920e-04
		,2.4942250470e-04
		,2.6205024740e-04
		,2.7494158550e-04
		,2.8808886430e-04
		,3.0148658030e-04
		,3.1512961840e-04
		,3.2901432390e-04
		,3.4313446950e-04
		,3.5748631980e-04
		////////////////////////////////
		,1.4463764590e-17
		,1.2504896240e-13
		,2.1200535250e-13
		,2.7283246240e-13
		,3.1581065950e-13
		,3.4658369810e-13
		,3.6892259200e-13
		,3.8563146470e-13
		,3.9845533510e-13
		,4.0866514960e-13
		,4.1713506250e-13
		,4.2448488200e-13
		,4.3122998370e-13
		,4.3762147620e-13
		,4.4397866250e-13
		,4.5055928270e-13
		,4.5757282880e-13
		,4.6530168700e-13
		,4.7405816330e-13
		,4.8425993650e-13
		,4.9643877800e-13
		,5.1095863610e-13
		,5.2859299180e-13
		,5.5066787970e-13
		,5.7876540370e-13
		,6.1491208100e-13
		,6.6189203630e-13
		,7.2341263180e-13
		,8.0458778210e-13
		,9.1224159220e-13
		,1.0555342760e-12
		,1.2469927480e-12
		,1.5035411700e-12
		,1.8479868170e-12
		,2.3114111690e-12
		,2.9357480960e-12
		,3.7780320240e-12
		,4.9155656330e-12
		,6.4533076380e-12
		,8.5339001050e-12
		,1.1351098450e-11
		,1.5168542710e-11
		,2.0344786560e-11
		,2.7104211310e-11
		,3.6002643340e-11
		,4.7976693530e-11
		,6.4111439270e-11
		,8.5880417340e-11
		,1.1528532740e-10
		,1.5504716760e-10
		,2.0886631530e-10
		,2.8177718570e-10
		,3.8063171760e-10
		,5.0955162470e-10
		,6.7595973170e-10
		,8.9707666200e-10
		,1.1909574460e-09
		,1.5816268650e-09
		,2.1010509600e-09
		,2.7917683140e-09
		,3.7103698110e-09
		,4.9321283260e-09
		,6.5571388840e-09
		,8.7184538220e-09
		,1.1592847800e-08
		,1.5415037230e-08
		,2.0496424580e-08
		,2.7249742050e-08
		,3.6221349780e-08
		,4.8133403150e-08
		,6.3938647870e-08
		,8.4866522000e-08
		,1.1246744060e-07
		,1.4894499340e-07
		,1.9706773840e-07
		,2.6041527240e-07
		,3.4358476180e-07
		,4.5243275640e-07
		,5.9434881980e-07
		,7.7855149100e-07
		,1.0163887380e-06
		,1.3216153390e-06
		,1.7106086280e-06
		,2.2024759760e-06
		,2.8190058110e-06
		,3.5844185080e-06
		,4.5248946210e-06
		,5.6678884940e-06
		,7.0412735180e-06
		,8.6724012670e-06
		,1.0587181700e-05
		,1.2809280550e-05
		,1.5359515000e-05
		,1.8255510930e-05
		,2.1511600300e-05
		,2.5138945210e-05
		,2.9145795550e-05
		,3.3537892910e-05
		,3.8318947070e-05
		,4.3491014360e-05
		,4.9054795660e-05
		,5.5010163790e-05
		,6.1356408990e-05
		,6.8092525230e-05
		,7.5217836610e-05
		,8.2730761500e-05
		,9.0630240740e-05
		,9.8915558330e-05
		,1.0758620680e-04
		,1.1664181740e-04
		,1.2608226980e-04
		,1.3590092420e-04
		,1.4561685420e-04
		,1.5568896370e-04
		,1.6611214690e-04
		,1.7688214310e-04
		,1.8798893370e-04
		,1.9930898520e-04
		,2.1093630220e-04
		,2.2286303030e-04
		,2.3508272270e-04
		////////////////////////////////
		,6.2135782150e-18
		,1.4207045460e-13
		,2.4091802620e-13
		,3.1002931530e-13
		,3.5881162310e-13
		,3.9359503540e-13
		,4.1881522860e-13
		,4.3754221180e-13
		,4.5171660630e-13
		,4.6281864200e-13
		,4.7177761330e-13
		,4.7932501960e-13
		,4.8589916490e-13
		,4.9174891260e-13
		,4.9720380010e-13
		,5.0237045320e-13
		,5.0729195040e-13
		,5.1217773170e-13
		,5.1698591940e-13
		,5.2183123300e-13
		,5.2679711420e-13
		,5.3189452840e-13
		,5.3727286670e-13
		,5.4295171010e-13
		,5.4910196300e-13
		,5.5595186300e-13
		,5.6367147880e-13
		,5.7238049050e-13
		,5.8234875200e-13
		,5.9427721610e-13
		,6.0877049610e-13
		,6.2673720890e-13
		,6.4934689690e-13
		,6.7810198160e-13
		,7.1516051340e-13
		,7.6340394820e-13
		,8.2663530860e-13
		,9.1004103780e-13
		,1.0206181290e-12
		,1.1678067280e-12
		,1.3643414670e-12
		,1.6274636690e-12
		,1.9805555630e-12
		,2.4552619930e-12
		,3.0943623150e-12
		,3.9559627490e-12
		,5.1188612430e-12
		,6.6900266320e-12
		,8.8147245440e-12
		,1.1612990230e-11
		,1.5214552230e-11
		,2.0040706150e-11
		,2.6518386200e-11
		,3.5226261120e-11
		,4.6948809960e-11
		,6.2750243110e-11
		,8.4075574720e-11
		,1.1288759520e-10
		,1.5185390720e-10
		,2.0401008050e-10
		,2.6983329300e-10
		,3.5712135310e-10
		,4.7291202940e-10
		,6.2656047680e-10
		,8.3050412040e-10
		,1.1012777300e-09
		,1.4608652600e-09
		,1.9384964360e-09
		,2.5730341270e-09
		,3.4161442870e-09
		,4.5365033950e-09
		,6.0253790040e-09
		,8.0040228810e-09
		,1.0633455640e-08
		,1.4127394830e-08
		,1.8769308020e-08
		,2.4934856180e-08
		,3.3121353960e-08
		,4.3986321160e-08
		,5.8379253470e-08
		,7.7353076390e-08
		,1.0245801480e-07
		,1.3563110630e-07
		,1.7939389240e-07
		,2.3701188540e-07
		,3.1268776810e-07
		,4.1178992710e-07
		,5.4111459090e-07
		,7.0917442320e-07
		,9.2649926710e-07
		,1.2059250780e-06
		,1.5628367800e-06
		,2.0153214830e-06
		,2.5841833690e-06
		,3.2927745650e-06
		,4.1666107890e-06
		,5.2327674900e-06
		,6.5190914960e-06
		,8.0532837150e-06
		,9.8619712540e-06
		,1.1969855640e-05
		,1.4399035330e-05
		,1.7168565280e-05
		,2.0294266920e-05
		,2.3788729740e-05
		,2.7661595240e-05
		,3.1919804290e-05
		,3.6568057670e-05
		,4.1609226510e-05
		,4.7044760830e-05
		,5.2875168700e-05
		,5.9100083900e-05
		,6.5718797890e-05
		,7.2730301000e-05
		,8.0133665510e-05
		,8.7927521720e-05
		,9.6110798300e-05
		,1.0468257050e-04
		,1.1364208080e-04
		,1.2298870150e-04
		,1.3227418970e-04
		////////////////////////////////
		,-6.7882977870e-18
		,1.6052685250e-13
		,2.7190865040e-13
		,3.4951460290e-13
		,4.0407334650e-13
		,4.4273356320e-13
		,4.7061945430e-13
		,4.9100639580e-13
		,5.0626845740e-13
		,5.1806544070e-13
		,5.2745927000e-13
		,5.3520034670e-13
		,5.4182326220e-13
		,5.4771003120e-13
		,5.5305239240e-13
		,5.5803132770e-13
		,5.6280270290e-13
		,5.6738536810e-13
		,5.7188996990e-13
		,5.7635227640e-13
		,5.8074811140e-13
		,5.8518942700e-13
		,5.8956374890e-13
		,5.9404521880e-13
		,5.9852350350e-13
		,6.0307609210e-13
		,6.0772538540e-13
		,6.1247430760e-13
		,6.1734583380e-13
		,6.2245489220e-13
		,6.2777798560e-13
		,6.3345171190e-13
		,6.3952724310e-13
		,6.4605684790e-13
		,6.5320370240e-13
		,6.6120147480e-13
		,6.7031401460e-13
		,6.8098150550e-13
		,6.9367634930e-13
		,7.0902958060e-13
		,7.2805064640e-13
		,7.5184031990e-13
		,7.8202989270e-13
		,8.2092936490e-13
		,8.7136771470e-13
		,9.3736810920e-13
		,1.0241546920e-12
		,1.1390332110e-12
		,1.2917251020e-12
		,1.4953502490e-12
		,1.7676712520e-12
		,2.1327345330e-12
		,2.6230596620e-12
		,3.2827576710e-12
		,4.1716647080e-12
		,5.3574811750e-12
		,6.8409549680e-12
		,8.8189463420e-12
		,1.1461595130e-11
		,1.4998885520e-11
		,1.9741456590e-11
		,2.6110399860e-11
		,3.4676321290e-11
		,4.6212560560e-11
		,6.1768481530e-11
		,8.2768717150e-11
		,1.0945554210e-10
		,1.4430728860e-10
		,1.9043384440e-10
		,2.5150803520e-10
		,3.3240476240e-10
		,4.3959643890e-10
		,5.8167917030e-10
		,7.7006441020e-10
		,1.0199159420e-09
		,1.3513800730e-09
		,1.7912192020e-09
		,2.3749882200e-09
		,3.1499215490e-09
		,4.1787634930e-09
		,5.5448472630e-09
		,7.3588247840e-09
		,9.7675735790e-09
		,1.2965972100e-08
		,1.7212444860e-08
		,2.2849448870e-08
		,3.0330421840e-08
		,4.0241558320e-08
		,5.3290366870e-08
		,7.0566041050e-08
		,9.3415520320e-08
		,1.2360098560e-07
		,1.6341865310e-07
		,2.1584645670e-07
		,2.8472421660e-07
		,3.7496872150e-07
		,4.9282343240e-07
		,6.4613795260e-07
		,8.4466584040e-07
		,1.1003606140e-06
		,1.4276396830e-06
		,1.8435760170e-06
		,2.3679704330e-06
		,3.0232570920e-06
		,3.8342047610e-06
		,4.8273998700e-06
		,6.0305249250e-06
		,7.4714922420e-06
		,9.1775180870e-06
		,1.1174238190e-05
		,1.3484962770e-05
		,1.6130145340e-05
		,1.9127101940e-05
		,2.2489943700e-05
		,2.6229719840e-05
		,3.0354697100e-05
		,3.4870781190e-05
		,3.9781851560e-05
		,4.5090233300e-05
		,5.0797059270e-05
		,5.6902605570e-05
		////////////////////////////////
		,-1.6239460660e-17
		,1.7790017850e-13
		,3.0111321360e-13
		,3.8683197120e-13
		,4.4686575780e-13
		,4.8936873380e-13
		,5.1983588890e-13
		,5.4205468510e-13
		,5.5866528660e-13
		,5.7138216570e-13
		,5.8151637090e-13
		,5.8983208880e-13
		,5.9695001540e-13
		,6.0320861730e-13
		,6.0894709180e-13
		,6.1430355150e-13
		,6.1936947920e-13
		,6.2432914660e-13
		,6.2913096390e-13
		,6.3389622980e-13
		,6.3861162910e-13
		,6.4329825710e-13
		,6.4803631820e-13
		,6.5273344180e-13
		,6.5745009420e-13
		,6.6217682440e-13
		,6.6694934840e-13
		,6.7178714280e-13
		,6.7662498940e-13
		,6.8149870870e-13
		,6.8642349560e-13
		,6.9139292750e-13
		,6.9639906740e-13
		,7.0154833250e-13
		,7.0674422680e-13
		,7.1202768790e-13
		,7.1745881690e-13
		,7.2311975020e-13
		,7.2894438180e-13
		,7.3499276050e-13
		,7.4132378640e-13
		,7.4807907040e-13
		,7.5529949770e-13
		,7.6328322400e-13
		,7.7219044890e-13
		,7.8226982690e-13
		,7.9395893120e-13
		,8.0774833450e-13
		,8.2440483420e-13
		,8.4481965930e-13
		,8.7025561050e-13
		,9.0244929980e-13
		,9.4359480680e-13
		,9.9685801010e-13
		,1.0662939810e-12
		,1.1574974930e-12
		,1.2778843180e-12
		,1.4375915300e-12
		,1.6503560560e-12
		,1.9345870910e-12
		,2.3152905840e-12
		,2.8265261760e-12
		,3.4564244600e-12
		,4.2838030160e-12
		,5.3826484730e-12
		,6.8453623950e-12
		,8.7972662100e-12
		,1.1407126720e-11
		,1.4902959190e-11
		,1.9593477650e-11
		,2.5896630750e-11
		,3.4378812630e-11
		,4.5441273090e-11
		,5.9544029620e-11
		,7.8159247220e-11
		,1.0273964180e-10
		,1.3521607470e-10
		,1.7814620290e-10
		,2.3491963610e-10
		,3.1003180830e-10
		,4.0944530050e-10
		,5.4106883640e-10
		,7.1539578240e-10
		,9.4635906140e-10
		,1.2524487970e-09
		,1.6582101010e-09
		,2.1962272620e-09
		,2.9097575520e-09
		,3.8562248960e-09
		,5.1118521310e-09
		,6.7777988500e-09
		,8.9882897280e-09
		,1.1921367690e-08
		,1.5813101350e-08
		,2.0976373400e-08
		,2.7815913630e-08
		,3.6801507860e-08
		,4.8699539490e-08
		,6.4443040800e-08
		,8.5257045950e-08
		,1.1274491630e-07
		,1.4899774280e-07
		,1.9673075380e-07
		,2.5945084040e-07
		,3.4165823750e-07
		,4.4908320700e-07
		,5.8895482820e-07
		,7.7029315790e-07
		,1.0042081750e-06
		,1.3041790210e-06
		,1.6862773250e-06
		,2.1692896470e-06
		,2.7746912620e-06
		,3.5264294580e-06
		,4.4504927530e-06
		,5.5742673640e-06
		,6.9257276080e-06
		,8.5325310770e-06
		,1.0421115540e-05
		,1.2615903880e-05
		,1.5138682730e-05
		////////////////////////////////
		,-1.5681886460e-19
		,1.9469766240e-13
		,3.2968820410e-13
		,4.2381024650e-13
		,4.8985570370e-13
		,5.3661535810e-13
		,5.7017763850e-13
		,5.9466784680e-13
		,6.1299171960e-13
		,6.2706241250e-13
		,6.3823055400e-13
		,6.4741400360e-13
		,6.5526624900e-13
		,6.6216293480e-13
		,6.6852059110e-13
		,6.7440187750e-13
		,6.8002495390e-13
		,6.8546683950e-13
		,6.9076951620e-13
		,6.9598995220e-13
		,7.0121587090e-13
		,7.0640972870e-13
		,7.1163089570e-13
		,7.1678418140e-13
		,7.2198112000e-13
		,7.2724416460e-13
		,7.3247358180e-13
		,7.3777996590e-13
		,7.4313324030e-13
		,7.4844197410e-13
		,7.5381216670e-13
		,7.5924439220e-13
		,7.6465834210e-13
		,7.7010696360e-13
		,7.7563918350e-13
		,7.8120388200e-13
		,7.8681291220e-13
		,7.9245076580e-13
		,7.9812303000e-13
		,8.0388364430e-13
		,8.0969710160e-13
		,8.1556721370e-13
		,8.2153627570e-13
		,8.2763922050e-13
		,8.3379798470e-13
		,8.4012227470e-13
		,8.4655386940e-13
		,8.5325302070e-13
		,8.6017534480e-13
		,8.6746897950e-13
		,8.7518081510e-13
		,8.8340797410e-13
		,8.9241294810e-13
		,9.0238653570e-13
		,9.1367320840e-13
		,9.2658224370e-13
		,9.4176989690e-13
		,9.5996140130e-13
		,9.8210991430e-13
		,1.0095506090e-12
		,1.0441502720e-12
		,1.0881851190e-12
		,1.1450333420e-12
		,1.2187108480e-12
		,1.3152524400e-12
		,1.4426134910e-12
		,1.6115065030e-12
		,1.8360856100e-12
		,2.1152112410e-12
		,2.4702835980e-12
		,2.9383687830e-12
		,3.5574303430e-12
		,4.3783413800e-12
		,5.4690030690e-12
		,6.9226865880e-12
		,8.8642434160e-12
		,1.1462575650e-11
		,1.4946014720e-11
		,1.9603379490e-11
		,2.5396629040e-11
		,3.3019557450e-11
		,4.3056657650e-11
		,5.6280540840e-11
		,7.3711603860e-11
		,9.6698014200e-11
		,1.2703113600e-10
		,1.6707870670e-10
		,2.1997651830e-10
		,2.8987771380e-10
		,3.8228763840e-10
		,5.0450241800e-10
		,6.6619499150e-10
		,8.8019159520e-10
		,1.1635028810e-09
		,1.5386919280e-09
		,2.0356644510e-09
		,2.6941107680e-09
		,3.5667172470e-09
		,4.7233579620e-09
		,6.2567277620e-09
		,8.2897834720e-09
		,1.0985604730e-08
		,1.4560456440e-08
		,1.9294381810e-08
		,2.5494723680e-08
		,3.3703037230e-08
		,4.4564425150e-08
		,5.8927802040e-08
		,7.7907789040e-08
		,1.0296390240e-07
		,1.3600093910e-07
		,1.7949477340e-07
		,2.3664774160e-07
		,3.1157711030e-07
		,4.0953844460e-07
		,5.3718256400e-07
		,7.0283975860e-07
		,9.1681801090e-07
		,1.1916924140e-06
		,1.5425535160e-06
		,1.9871726390e-06
		////////////////////////////////
		,-2.7154209700e-18
		,2.0883294700e-13
		,3.5475007720e-13
		,4.5724574550e-13
		,5.2982623800e-13
		,5.8172664620e-13
		,6.1938107120e-13
		,6.4714216510e-13
		,6.6814719190e-13
		,6.8435510070e-13
		,6.9731624800e-13
		,7.0798974380e-13
		,7.1705304350e-13
		,7.2508705410e-13
		,7.3230910020e-13
		,7.3909320760e-13
		,7.4546344800e-13
		,7.5160764380e-13
		,7.5761722570e-13
		,7.6353678670e-13
		,7.6938084270e-13
		,7.7519215910e-13
		,7.8095387000e-13
		,7.8675343770e-13
		,7.9259566620e-13
		,7.9838050890e-13
		,8.0428336060e-13
		,8.1013289940e-13
		,8.1607016170e-13
		,8.2201650970e-13
		,8.2793539180e-13
		,8.3399405710e-13
		,8.4004071270e-13
		,8.4612616510e-13
		,8.5224148520e-13
		,8.5838818730e-13
		,8.6456371290e-13
		,8.7081202810e-13
		,8.7708384070e-13
		,8.8336364240e-13
		,8.8974970440e-13
		,8.9614192790e-13
		,9.0255916300e-13
		,9.0905440950e-13
		,9.1559539740e-13
		,9.2215831620e-13
		,9.2877460020e-13
		,9.3549385480e-13
		,9.4225817220e-13
		,9.4905538590e-13
		,9.5601535800e-13
		,9.6300848750e-13
		,9.7004741080e-13
		,9.7729060440e-13
		,9.8461123500e-13
		,9.9217550720e-13
		,9.9991501740e-13
		,1.0079600460e-12
		,1.0163283980e-12
		,1.0251976610e-12
		,1.0346781700e-12
		,1.0449524720e-12
		,1.0562345490e-12
		,1.0689096030e-12
		,1.0833715010e-12
		,1.1002477790e-12
		,1.1202415320e-12
		,1.1444270050e-12
		,1.1743333040e-12
		,1.2116769900e-12
		,1.2591124280e-12
		,1.3200939940e-12
		,1.3991896280e-12
		,1.5027481080e-12
		,1.6325219730e-12
		,1.7909700400e-12
		,1.9973277220e-12
		,2.2674540190e-12
		,2.6225423020e-12
		,3.0900412540e-12
		,3.7088597980e-12
		,4.5303831770e-12
		,5.6241113770e-12
		,7.0836690810e-12
		,9.0357673490e-12
		,1.1506788190e-11
		,1.4683768390e-11
		,1.8852347010e-11
		,2.4326194610e-11
		,3.1517078150e-11
		,4.0966300510e-11
		,5.3397701190e-11
		,6.9762765510e-11
		,9.1318830180e-11
		,1.1972770510e-10
		,1.5718757480e-10
		,2.0660655810e-10
		,2.7183320320e-10
		,3.5796218060e-10
		,4.7173999920e-10
		,6.2210234300e-10
		,8.2088761610e-10
		,1.0837782080e-09
		,1.4315318730e-09
		,1.8917268720e-09
		,2.5008959650e-09
		,3.3074800270e-09
		,4.3757131360e-09
		,5.7907882780e-09
		,7.6657067560e-09
		,1.0150372700e-08
		,1.3439451820e-08
		,1.7729965270e-08
		,2.3407099280e-08
		,3.0916672480e-08
		,4.0846199400e-08
		,5.3968270100e-08
		,7.1298224440e-08
		,9.4165499570e-08
		,1.2430603320e-07
		,1.6397810550e-07
		////////////////////////////////
		,8.8243966850e-18
		,2.1894934640e-13
		,3.7284613000e-13
		,4.8181662810e-13
		,5.5983227030e-13
		,6.1636677690e-13
		,6.5814639950e-13
		,6.8969401570e-13
		,7.1410187880e-13
		,7.3355111880e-13
		,7.4956342510e-13
		,7.6313764470e-13
		,7.7490653560e-13
		,7.8542327790e-13
		,7.9500169210e-13
		,8.0386724840e-13
		,8.1218787470e-13
		,8.2006528840e-13
		,8.2763504320e-13
		,8.3493948670e-13
		,8.4202540470e-13
		,8.4898193050e-13
		,8.5582211830e-13
		,8.6256419150e-13
		,8.6928814560e-13
		,8.7594192090e-13
		,8.8259047460e-13
		,8.8924612970e-13
		,8.9590684980e-13
		,9.0259764650e-13
		,9.0931789330e-13
		,9.1604931430e-13
		,9.2278245850e-13
		,9.2958839230e-13
		,9.3644246960e-13
		,9.4329717350e-13
		,9.5016884780e-13
		,9.5715247390e-13
		,9.6412560450e-13
		,9.7119084480e-13
		,9.7825206450e-13
		,9.8537745800e-13
		,9.9254269270e-13
		,9.9972662080e-13
		,1.0070037550e-12
		,1.0143114880e-12
		,1.0216825080e-12
		,1.0290512290e-12
		,1.0364818280e-12
		,1.0439847980e-12
		,1.0514778990e-12
		,1.0591126110e-12
		,1.0667058630e-12
		,1.0744041750e-12
		,1.0821936560e-12
		,1.0899892990e-12
		,1.0978788790e-12
		,1.1058705420e-12
		,1.1138832490e-12
		,1.1219946960e-12
		,1.1302284340e-12
		,1.1385289050e-12
		,1.1470076950e-12
		,1.1556160330e-12
		,1.1643791410e-12
		,1.1734636410e-12
		,1.1828784090e-12
		,1.1925883040e-12
		,1.2028846930e-12
		,1.2138597900e-12
		,1.2256317100e-12
		,1.2385036720e-12
		,1.2528789950e-12
		,1.2691744700e-12
		,1.2880101160e-12
		,1.3103170010e-12
		,1.3370949130e-12
		,1.3699302370e-12
		,1.4109201920e-12
		,1.4627459830e-12
		,1.5278324860e-12
		,1.6032758460e-12
		,1.6994402270e-12
		,1.8228467760e-12
		,1.9823959290e-12
		,2.1902847520e-12
		,2.4623857160e-12
		,2.8203696570e-12
		,3.2933642780e-12
		,3.9204713870e-12
		,4.7545310810e-12
		,5.8364534210e-12
		,7.1871471480e-12
		,8.9517944980e-12
		,1.1259652190e-11
		,1.4278044640e-11
		,1.8229575690e-11
		,2.3410157410e-11
		,3.0207498860e-11
		,3.9132569700e-11
		,5.0859455530e-11
		,6.6277595940e-11
		,8.6560997980e-11
		,1.1326018630e-10
		,1.4842366960e-10
		,1.9475881290e-10
		,2.5582614840e-10
		,3.3634873200e-10
		,4.4258804960e-10
		,5.8282277000e-10
		,7.6800980510e-10
		,1.0126552280e-09
		,1.3359708010e-09
		,1.7634076270e-09
		,2.3286910450e-09
		,3.0765213830e-09
		,4.0661623880e-09
		,5.3762127460e-09
		,7.1109593530e-09
		,9.4065203620e-09
		,1.2385430850e-08
		////////////////////////////////
		,-3.0809355580e-18
		,1.8616858690e-14
		,3.1804677180e-14
		,4.1219236380e-14
		,4.8030757350e-14
		,5.3013034460e-14
		,5.6757731400e-14
		,5.9611251560e-14
		,6.1886579860e-14
		,6.3723603950e-14
		,6.5309519520e-14
		,6.6665421990e-14
		,6.7901644540e-14
		,6.8979442620e-14
		,7.0025440930e-14
		,7.1027890800e-14
		,7.1965644570e-14
		,7.2890970860e-14
		,7.3766534940e-14
		,7.4617505120e-14
		,7.5435109030e-14
		,7.6264983790e-14
		,7.7064938570e-14
		,7.7852674720e-14
		,7.8555611480e-14
		,7.9326481750e-14
		,8.0018818590e-14
		,8.0712251980e-14
		,8.1447928410e-14
		,8.2136453450e-14
		,8.2796259500e-14
		,8.3456222190e-14
		,8.4112216440e-14
		,8.4804448850e-14
		,8.5474541520e-14
		,8.6159724720e-14
		,8.6796033400e-14
		,8.7471608790e-14
		,8.8136375390e-14
		,8.8826884660e-14
		,8.9514260950e-14
		,9.0204404700e-14
		,9.0883687450e-14
		,9.1580671550e-14
		,9.2273321690e-14
		,9.2997562740e-14
		,9.3711203860e-14
		,9.4387823580e-14
		,9.5122768980e-14
		,9.5857923240e-14
		,9.6583469700e-14
		,9.7312671300e-14
		,9.8053517150e-14
		,9.8795825060e-14
		,9.9559280590e-14
		,1.0030352050e-13
		,1.0106640170e-13
		,1.0182661980e-13
		,1.0261158850e-13
		,1.0338710600e-13
		,1.0423097470e-13
		,1.0505907410e-13
		,1.0589672910e-13
		,1.0676555730e-13
		,1.0761313340e-13
		,1.0851229930e-13
		,1.0942039420e-13
		,1.1043297400e-13
		,1.1146910340e-13
		,1.1255316750e-13
		,1.1376500500e-13
		,1.1503454160e-13
		,1.1652302140e-13
		,1.1811870140e-13
		,1.2008725860e-13
		,1.2237172470e-13
		,1.2512577270e-13
		,1.2849952460e-13
		,1.3260989270e-13
		,1.3782683020e-13
		,1.4453005440e-13
		,1.5311118820e-13
		,1.6430820530e-13
		,1.7897223280e-13
		,1.9784422090e-13
		,2.1959651610e-13
		,2.4703778470e-13
		,2.8248617250e-13
		,3.2847349470e-13
		,3.8833246080e-13
		,4.6665064470e-13
		,5.6945308410e-13
		,7.0502636040e-13
		,8.8453892840e-13
		,1.1229664430e-12
		,1.4376849970e-12
		,1.8233390200e-12
		,2.3251135270e-12
		,2.9786581510e-12
		,3.8305027920e-12
		,4.9417621680e-12
		,6.3897376020e-12
		,8.2752766040e-12
		,1.0738407810e-11
		,1.3959647390e-11
		,1.8175476450e-11
		,2.3696500960e-11
		,3.0931689420e-11
		,4.0419340200e-11
		,5.2868298160e-11
		,6.9212470450e-11
		,9.0682937350e-11
		,1.1890323330e-10
		,1.5601522100e-10
		,2.0484587110e-10
		,2.6909792980e-10
		,3.5369406650e-10
		,4.6515438590e-10
		,6.1208027590e-10
		,8.0584631390e-10
		,1.0615014220e-09
		////////////////////////////////
		,9.5554258570e-18
		,2.3203680500e-13
		,3.9607646170e-13
		,5.1317798850e-13
		,5.9787179100e-13
		,6.6023782170e-13
		,7.0718420190e-13
		,7.4349264560e-13
		,7.7246912770e-13
		,7.9641670350e-13
		,8.1693919880e-13
		,8.3504042100e-13
		,8.5153165590e-13
		,8.6689846350e-13
		,8.8148359200e-13
		,8.9550081530e-13
		,9.0914463930e-13
		,9.2254471740e-13
		,9.3567144270e-13
		,9.4872438630e-13
		,9.6152951110e-13
		,9.7429646560e-13
		,9.8684338040e-13
		,9.9928983090e-13
		,1.0115700770e-12
		,1.0237110090e-12
		,1.0357170150e-12
		,1.0474587010e-12
		,1.0590262970e-12
		,1.0704024170e-12
		,1.0815619950e-12
		,1.0924538600e-12
		,1.1031396260e-12
		,1.1135516750e-12
		,1.1237131370e-12
		,1.1337561720e-12
		,1.1435438700e-12
		,1.1531588350e-12
		,1.1626831530e-12
		,1.1720699330e-12
		,1.1813794330e-12
		,1.1906115490e-12
		,1.1998411570e-12
		,1.2090659100e-12
		,1.2182741100e-12
		,1.2275038760e-12
		,1.2368132710e-12
		,1.2461290890e-12
		,1.2554894480e-12
		,1.2648845300e-12
		,1.2743241010e-12
		,1.2838588620e-12
		,1.2933909080e-12
		,1.3030011220e-12
		,1.3127079370e-12
		,1.3224247240e-12
		,1.3322351360e-12
		,1.3421177620e-12
		,1.3520203880e-12
		,1.3620129300e-12
		,1.3720597770e-12
		,1.3822170620e-12
		,1.3923961210e-12
		,1.4026322530e-12
		,1.4129491110e-12
		,1.4232810070e-12
		,1.4337745650e-12
		,1.4442812820e-12
		,1.4549171300e-12
		,1.4655572080e-12
		,1.4762984280e-12
		,1.4871198530e-12
		,1.4980085850e-12
		,1.5090060830e-12
		,1.5201049860e-12
		,1.5312127130e-12
		,1.5424925450e-12
		,1.5539194710e-12
		,1.5653849850e-12
		,1.5770843240e-12
		,1.5888933690e-12
		,1.6009280930e-12
		,1.6131911600e-12
		,1.6257887240e-12
		,1.6387268960e-12
		,1.6521413340e-12
		,1.6661672250e-12
		,1.6809859700e-12
		,1.6968213150e-12
		,1.7140168440e-12
		,1.7330156660e-12
		,1.7543200490e-12
		,1.7787684320e-12
		,1.8057005910e-12
		,1.8362598560e-12
		,1.8721683740e-12
		,1.9152318410e-12
		,1.9675505020e-12
		,2.0316029650e-12
		,2.1116708150e-12
		,2.2130549010e-12
		,2.3429349220e-12
		,2.5108481980e-12
		,2.7298641200e-12
		,3.0034648950e-12
		,3.3456966200e-12
		,3.7869182060e-12
		,4.3571290540e-12
		,5.0957529930e-12
		,6.0545532590e-12
		,7.3011515130e-12
		,8.9243555790e-12
		,1.1040584470e-11
		,1.3796360650e-11
		,1.7389919600e-11
		,2.2086682980e-11
		,2.8228364370e-11
		,3.6269362880e-11
		,4.6805121210e-11
		,6.0619371610e-11
		,7.8744417220e-11
		////////////////////////////////
		,6.8923910130e-18
		,2.3670484400e-13
		,4.0440883670e-13
		,5.2431302480e-13
		,6.1125301890e-13
		,6.7556092420e-13
		,7.2410329770e-13
		,7.6190774040e-13
		,7.9231944160e-13
		,8.1763498190e-13
		,8.3949729700e-13
		,8.5896601370e-13
		,8.7685534190e-13
		,8.9365898730e-13
		,9.0981739510e-13
		,9.2545019280e-13
		,9.4083564170e-13
		,9.5594867770e-13
		,9.7099331030e-13
		,9.8599387230e-13
		,1.0009352730e-12
		,1.0158530200e-12
		,1.0307558850e-12
		,1.0456795850e-12
		,1.0605903340e-12
		,1.0754466750e-12
		,1.0903234320e-12
		,1.1051120470e-12
		,1.1198804550e-12
		,1.1345849510e-12
		,1.1492019310e-12
		,1.1636835150e-12
		,1.1780696470e-12
		,1.1923355240e-12
		,1.2064112300e-12
		,1.2202963980e-12
		,1.2340277370e-12
		,1.2475193500e-12
		,1.2607622040e-12
		,1.2737967680e-12
		,1.2865541150e-12
		,1.2990298590e-12
		,1.3112607080e-12
		,1.3232722480e-12
		,1.3350315310e-12
		,1.3465668060e-12
		,1.3579262680e-12
		,1.3691279850e-12
		,1.3802386880e-12
		,1.3912845390e-12
		,1.4022345210e-12
		,1.4131897240e-12
		,1.4241328650e-12
		,1.4350673380e-12
		,1.4460416530e-12
		,1.4570582620e-12
		,1.4681517350e-12
		,1.4792275570e-12
		,1.4904259320e-12
		,1.5016529220e-12
		,1.5130029330e-12
		,1.5243947170e-12
		,1.5358100510e-12
		,1.5473343600e-12
		,1.5589598130e-12
		,1.5706217120e-12
		,1.5823943110e-12
		,1.5941762030e-12
		,1.6060837810e-12
		,1.6180729730e-12
		,1.6301341180e-12
		,1.6423061200e-12
		,1.6545704400e-12
		,1.6668334020e-12
		,1.6792619420e-12
		,1.6917410280e-12
		,1.7042600590e-12
		,1.7169650850e-12
		,1.7296661420e-12
		,1.7425280260e-12
		,1.7554068280e-12
		,1.7684387290e-12
		,1.7815467080e-12
		,1.7947522280e-12
		,1.8081254150e-12
		,1.8215542640e-12
		,1.8351246200e-12
		,1.8488642080e-12
		,1.8627404480e-12
		,1.8768397030e-12
		,1.8911839050e-12
		,1.9057631330e-12
		,1.9206782690e-12
		,1.9360274280e-12
		,1.9519176000e-12
		,1.9684568220e-12
		,1.9858764110e-12
		,2.0043718670e-12
		,2.0244033720e-12
		,2.0458744300e-12
		,2.0687764770e-12
		,2.0942655850e-12
		,2.1229605160e-12
		,2.1558506670e-12
		,2.1943348100e-12
		,2.2399711860e-12
		,2.2950990360e-12
		,2.3627918680e-12
		,2.4472576930e-12
		,2.5541645480e-12
		,2.6890944150e-12
		,2.8524264870e-12
		,3.0574281630e-12
		,3.3185832170e-12
		,3.6527653710e-12
		,4.0820051810e-12
		,4.6351291100e-12
		,5.3497578520e-12
		,6.2751292500e-12
		,7.4757149610e-12
		,9.0355902310e-12
		////////////////////////////////
		,-3.6553156220e-18
		,2.4081552550e-13
		,4.1148697440e-13
		,5.3380998150e-13
		,6.2268041470e-13
		,6.8852656210e-13
		,7.3841893760e-13
		,7.7746743520e-13
		,8.0896325280e-13
		,8.3534536460e-13
		,8.5822396690e-13
		,8.7875361580e-13
		,8.9768554820e-13
		,9.1555315440e-13
		,9.3279139660e-13
		,9.4962365660e-13
		,9.6621963760e-13
		,9.8268283230e-13
		,9.9909454160e-13
		,1.0155623840e-12
		,1.0320381100e-12
		,1.0485982710e-12
		,1.0652232320e-12
		,1.0819854170e-12
		,1.0988418540e-12
		,1.1157709230e-12
		,1.1327683430e-12
		,1.1498709790e-12
		,1.1670322550e-12
		,1.1842647010e-12
		,1.2015045620e-12
		,1.2188080750e-12
		,1.2361512200e-12
		,1.2534727470e-12
		,1.2707848230e-12
		,1.2881224330e-12
		,1.3053820840e-12
		,1.3226390720e-12
		,1.3397941860e-12
		,1.3568174540e-12
		,1.3737961280e-12
		,1.3906085980e-12
		,1.4072511040e-12
		,1.4237663580e-12
		,1.4400271620e-12
		,1.4560898580e-12
		,1.4719031150e-12
		,1.4875156010e-12
		,1.5027779760e-12
		,1.5177835500e-12
		,1.5325257460e-12
		,1.5469745900e-12
		,1.5611561900e-12
		,1.5750857420e-12
		,1.5887453880e-12
		,1.6022665550e-12
		,1.6156008410e-12
		,1.6288148200e-12
		,1.6419800290e-12
		,1.6550003370e-12
		,1.6680665960e-12
		,1.6811459610e-12
		,1.6942061620e-12
		,1.7072974330e-12
		,1.7204574200e-12
		,1.7337327010e-12
		,1.7470006720e-12
		,1.7603956320e-12
		,1.7738466740e-12
		,1.7873627760e-12
		,1.8009725550e-12
		,1.8146700060e-12
		,1.8284914700e-12
		,1.8423219150e-12
		,1.8563575710e-12
		,1.8704011110e-12
		,1.8845646970e-12
		,1.8987722490e-12
		,1.9131453270e-12
		,1.9276152140e-12
		,1.9421112090e-12
		,1.9567858360e-12
		,1.9715369610e-12
		,1.9863524160e-12
		,2.0012897440e-12
		,2.0163589180e-12
		,2.0314755570e-12
		,2.0467734390e-12
		,2.0621230670e-12
		,2.0776410940e-12
		,2.0932449110e-12
		,2.1089374450e-12
		,2.1248035970e-12
		,2.1407777330e-12
		,2.1569142100e-12
		,2.1732205470e-12
		,2.1896935060e-12
		,2.2063546530e-12
		,2.2232467530e-12
		,2.2403956010e-12
		,2.2578675640e-12
		,2.2757126120e-12
		,2.2940651000e-12
		,2.3130055430e-12
		,2.3327435400e-12
		,2.3532822750e-12
		,2.3745319870e-12
		,2.3970277390e-12
		,2.4210910790e-12
		,2.4471191630e-12
		,2.4756746250e-12
		,2.5075607080e-12
		,2.5436900490e-12
		,2.5854297260e-12
		,2.6345523800e-12
		,2.6934227340e-12
		,2.7651619680e-12
		,2.8502421720e-12
		,2.9543225550e-12
		,3.0835323270e-12
		,3.2454101740e-12
		////////////////////////////////
		,1.4098250010e-17
		,1.1088229600e-12
		,1.9074379210e-12
		,2.4912017370e-12
		,2.9268322550e-12
		,3.2614653500e-12
		,3.5278113900e-12
		,3.7501675420e-12
		,3.9461503540e-12
		,4.1296989860e-12
		,4.3124622840e-12
		,4.5043588520e-12
		,4.7156326010e-12
		,4.9596585980e-12
		,5.2517722160e-12
		,5.6115723990e-12
		,6.0649242660e-12
		,6.6461342310e-12
		,7.4009302070e-12
		,8.3930988210e-12
		,9.7076015390e-12
		,1.1459682650e-11
		,1.3807249690e-11
		,1.6964577640e-11
		,2.1225043910e-11
		,2.6989628650e-11
		,3.4804275990e-11
		,4.5413114470e-11
		,5.9831393850e-11
		,7.9444829800e-11
		,1.0614589850e-10
		,1.4251944610e-10
		,1.9209749990e-10
		,2.5735490190e-10
		,3.4533130510e-10
		,4.6466110710e-10
		,6.2666102270e-10
		,8.4632774080e-10
		,1.1442415380e-09
		,1.5488499530e-09
		,2.0988924160e-09
		,2.8471252920e-09
		,3.8582250200e-09
		,5.1387104010e-09
		,6.8458442460e-09
		,9.1217022030e-09
		,1.2155445520e-08
		,1.6198735490e-08
		,2.1586074810e-08
		,2.8761600220e-08
		,3.8313952170e-08
		,5.1022272910e-08
		,6.7914168740e-08
		,9.0341031130e-08
		,1.2008160560e-07
		,1.5945374940e-07
		,2.1144502330e-07
		,2.7983176440e-07
		,3.6969865900e-07
		,4.8736872710e-07
		,6.4079295680e-07
		,8.3989933910e-07
		,1.0968292180e-06
		,1.4262124080e-06
		,1.8452504660e-06
		,2.3740261930e-06
		,3.0351323370e-06
		,3.8533913150e-06
		,4.8552731260e-06
		,6.0681090770e-06
		,7.5191688450e-06
		,9.2346717940e-06
		,1.1238994290e-05
		,1.3553918880e-05
		,1.6197692010e-05
		,1.9182278850e-05
		,2.2521291260e-05
		,2.6223160150e-05
		,3.0293626520e-05
		,3.4733877250e-05
		,3.9539045380e-05
		,4.4707564810e-05
		,5.0227986100e-05
		,5.6105359440e-05
		,6.2335567000e-05
		,6.8913580420e-05
		,7.5834077110e-05
		,8.3091829300e-05
		,9.0681443440e-05
		,9.8596795210e-05
		,1.0683269760e-04
		,1.1538385120e-04
		,1.2424241000e-04
		,1.3340409960e-04
		,1.4285927980e-04
		,1.5259531460e-04
		,1.6256338880e-04
		,1.7279878210e-04
		,1.8304660480e-04
		,1.9338342400e-04
		,2.0395451250e-04
		,2.1475174900e-04
		,2.2576692430e-04
		,2.3699242850e-04
		,2.4842176630e-04
		,2.6004562320e-04
		,2.7185855170e-04
		,2.8385465820e-04
		,2.9602766790e-04
		,3.0837245650e-04
		,3.2088386170e-04
		,3.3356090090e-04
		,3.4639634550e-04
		,3.5938360270e-04
		,3.7251873900e-04
		,3.8579909550e-04
		,3.9921959430e-04
		,4.1277535230e-04
		,4.2646762550e-04
		,4.4029289470e-04
		,4.5424545610e-04
		////////////////////////////////
		,-1.3106478490e-17
		,1.5949306780e-12
		,2.7090943810e-12
		,3.4917608430e-12
		,4.0458713480e-12
		,4.4425294480e-12
		,4.7308381120e-12
		,4.9447047690e-12
		,5.1075667900e-12
		,5.2356859710e-12
		,5.3402126470e-12
		,5.4291400480e-12
		,5.5081844050e-12
		,5.5818073450e-12
		,5.6534219920e-12
		,5.7263049210e-12
		,5.8036036330e-12
		,5.8881065320e-12
		,5.9830230990e-12
		,6.0935225970e-12
		,6.2257642080e-12
		,6.3876215340e-12
		,6.5895973750e-12
		,6.8460484660e-12
		,7.1762349710e-12
		,7.6063643380e-12
		,8.1717217790e-12
		,8.9205409640e-12
		,9.9180255710e-12
		,1.1252825420e-11
		,1.3045562620e-11
		,1.5460071040e-11
		,1.8718878160e-11
		,2.3125534330e-11
		,2.9091960410e-11
		,3.7179645160e-11
		,4.8154136810e-11
		,6.3059503330e-11
		,8.3298810950e-11
		,1.0995250270e-10
		,1.4539867230e-10
		,1.9329702990e-10
		,2.5809521310e-10
		,3.4584507500e-10
		,4.6478467740e-10
		,6.2613123380e-10
		,8.4516280990e-10
		,1.1426916610e-09
		,1.5470724230e-09
		,2.0663342220e-09
		,2.7461960950e-09
		,3.6512345240e-09
		,4.8561159250e-09
		,6.4602199470e-09
		,8.5957671080e-09
		,1.1438420980e-08
		,1.5221877200e-08
		,2.0256350530e-08
		,2.6953272790e-08
		,3.5857653620e-08
		,4.7690222730e-08
		,6.3402234000e-08
		,8.4246025370e-08
		,1.1186535110e-07
		,1.4838233330e-07
		,1.9647768030e-07
		,2.5983869180e-07
		,3.4308292020e-07
		,4.5210099610e-07
		,5.9432323290e-07
		,7.7901600390e-07
		,1.0175947380e-06
		,1.3238893010e-06
		,1.7143612040e-06
		,2.2082061810e-06
		,2.8272927620e-06
		,3.5959100580e-06
		,4.5402681510e-06
		,5.6877917800e-06
		,7.0662404810e-06
		,8.7027433640e-06
		,1.0622855830e-05
		,1.2849745120e-05
		,1.5403587370e-05
		,1.8301220870e-05
		,2.1556054480e-05
		,2.5178195870e-05
		,2.9174741490e-05
		,3.3550175290e-05
		,3.8306804730e-05
		,4.3445188830e-05
		,4.8964541130e-05
		,5.4863084670e-05
		,6.1138350920e-05
		,6.7787401170e-05
		,7.4806982970e-05
		,8.2193725170e-05
		,8.9944112070e-05
		,9.8054444220e-05
		,1.0652094230e-04
		,1.1534062150e-04
		,1.2451005080e-04
		,1.3402569160e-04
		,1.4388443690e-04
		,1.5408266570e-04
		,1.6431963040e-04
		,1.7464975350e-04
		,1.8527145800e-04
		,1.9617743000e-04
		,2.0735871410e-04
		,2.1880619790e-04
		,2.3051201780e-04
		,2.4246922490e-04
		,2.5467155730e-04
		,2.6711138320e-04
		,2.7978364050e-04
		,2.9268086250e-04
		,3.0579557190e-04
		,3.1912136510e-04
		,3.3265497060e-04
		,3.4638877240e-04
		////////////////////////////////
		,4.5948707630e-18
		,1.8043956520e-12
		,3.0541241200e-12
		,3.9240156260e-12
		,4.5336468040e-12
		,4.9651137460e-12
		,5.2745140110e-12
		,5.5003737760e-12
		,5.6691031940e-12
		,5.7987611910e-12
		,5.9016454010e-12
		,5.9863518930e-12
		,6.0586773080e-12
		,6.1226806880e-12
		,6.1809922220e-12
		,6.2357014530e-12
		,6.2881497150e-12
		,6.3393340800e-12
		,6.3900953360e-12
		,6.4410959520e-12
		,6.4927427450e-12
		,6.5456197560e-12
		,6.6004367100e-12
		,6.6580438450e-12
		,6.7197292350e-12
		,6.7879610440e-12
		,6.8652746900e-12
		,6.9550247080e-12
		,7.0614604140e-12
		,7.1903217980e-12
		,7.3493756800e-12
		,7.5491978570e-12
		,7.8039499310e-12
		,8.1329209960e-12
		,8.5620086470e-12
		,9.1266149550e-12
		,9.8745773220e-12
		,1.0870893170e-11
		,1.2203688120e-11
		,1.3992783020e-11
		,1.6400904750e-11
		,1.9649462790e-11
		,2.4039489410e-11
		,2.9980719250e-11
		,3.8030940170e-11
		,4.8704820460e-11
		,6.2653452390e-11
		,8.1437970340e-11
		,1.0677114090e-10
		,1.4098372600e-10
		,1.8724287970e-10
		,2.4985682790e-10
		,3.3468817340e-10
		,4.4971817600e-10
		,6.0581460420e-10
		,8.1197692610e-10
		,1.0760087760e-09
		,1.4271307100e-09
		,1.8941576270e-09
		,2.5154467310e-09
		,3.3420515780e-09
		,4.4419122360e-09
		,5.9054173950e-09
		,7.8527791680e-09
		,1.0443799470e-08
		,1.3890781860e-08
		,1.8475567440e-08
		,2.4571957720e-08
		,3.2675134220e-08
		,4.3440119880e-08
		,5.7731813650e-08
		,7.6689740750e-08
		,1.0179183460e-07
		,1.3488618640e-07
		,1.7858959330e-07
		,2.3618450860e-07
		,3.1189772460e-07
		,4.1113091660e-07
		,5.4072434220e-07
		,7.0924757690e-07
		,9.2730148780e-07
		,1.2078077590e-06
		,1.5662509180e-06
		,2.0208285910e-06
		,2.5924605250e-06
		,3.3046099930e-06
		,4.1828861420e-06
		,5.2544235820e-06
		,6.5470725470e-06
		,8.0884711010e-06
		,9.9050997200e-06
		,1.2021424550e-05
		,1.4459222860e-05
		,1.7237149110e-05
		,2.0370556280e-05
		,2.3871553210e-05
		,2.7749237870e-05
		,3.2010062730e-05
		,3.6658269220e-05
		,4.1696362590e-05
		,4.7125450470e-05
		,5.2945924530e-05
		,5.9157756660e-05
		,6.5760103830e-05
		,7.2751924880e-05
		,8.0108005190e-05
		,8.7835306310e-05
		,9.5936836380e-05
		,1.0440983920e-04
		,1.1325157240e-04
		,1.2245947730e-04
		,1.3203112740e-04
		,1.4196329620e-04
		,1.5183815770e-04
		,1.6197982410e-04
		,1.7244274460e-04
		,1.8322011800e-04
		,1.9430563170e-04
		,2.0569127700e-04
		,2.1737197290e-04
		,2.2933980540e-04
		////////////////////////////////
		,-1.2271016580e-17
		,1.9830944280e-12
		,3.3522659610e-12
		,4.3018325980e-12
		,4.9644756620e-12
		,5.4310776930e-12
		,5.7636961240e-12
		,6.0048539280e-12
		,6.1834722380e-12
		,6.3194893540e-12
		,6.4264651340e-12
		,6.5136463160e-12
		,6.5874208400e-12
		,6.6521318560e-12
		,6.7106948640e-12
		,6.7652287520e-12
		,6.8170543340e-12
		,6.8671925970e-12
		,6.9162223580e-12
		,6.9647714670e-12
		,7.0130288440e-12
		,7.0612779180e-12
		,7.1097256230e-12
		,7.1585972730e-12
		,7.2079655530e-12
		,7.2581059040e-12
		,7.3091459430e-12
		,7.3613762020e-12
		,7.4152253250e-12
		,7.4709051540e-12
		,7.5287866870e-12
		,7.5897757720e-12
		,7.6549455600e-12
		,7.7255651190e-12
		,7.8033821310e-12
		,7.8907643450e-12
		,7.9910479710e-12
		,8.1084046270e-12
		,8.2487947590e-12
		,8.4200789670e-12
		,8.6328906450e-12
		,8.9017267280e-12
		,9.2461005250e-12
		,9.6923796320e-12
		,1.0276387350e-11
		,1.1046738010e-11
		,1.2069138960e-11
		,1.3433084680e-11
		,1.5259740740e-11
		,1.7713969010e-11
		,2.1019771490e-11
		,2.5436014430e-11
		,3.1068443720e-11
		,3.8612958450e-11
		,4.8739985520e-11
		,6.2358683830e-11
		,8.0702886830e-11
		,1.0544796120e-10
		,1.3887035130e-10
		,1.8406481580e-10
		,2.4523935860e-10
		,3.2811943770e-10
		,4.3201106420e-10
		,5.6987009180e-10
		,7.5291520990e-10
		,9.9602653570e-10
		,1.3189968160e-09
		,1.7481535700e-09
		,2.3185162740e-09
		,3.0766621790e-09
		,4.0845321380e-09
		,5.4244815300e-09
		,7.2059756980e-09
		,9.5744571290e-09
		,1.2723070370e-08
		,1.6908138460e-08
		,2.2469548420e-08
		,2.9857530010e-08
		,3.9667720820e-08
		,5.2686906680e-08
		,6.9939086690e-08
		,9.2682114880e-08
		,1.2276080590e-07
		,1.6248008090e-07
		,2.1483133310e-07
		,2.8367416240e-07
		,3.7395321280e-07
		,4.9194972090e-07
		,6.4556275060e-07
		,8.4460837870e-07
		,1.1011162580e-06
		,1.4295927250e-06
		,1.8472095520e-06
		,2.3738704200e-06
		,3.0321069600e-06
		,3.8467664890e-06
		,4.8444767980e-06
		,6.0529063900e-06
		,7.4998782080e-06
		,9.2124264980e-06
		,1.1215902260e-05
		,1.3533229720e-05
		,1.6184385130e-05
		,1.9186097010e-05
		,2.2551826480e-05
		,2.6292004870e-05
		,3.0414188350e-05
		,3.4923695790e-05
		,3.9823785240e-05
		,4.5116059980e-05
		,5.0801056130e-05
		,5.6878497020e-05
		,6.3347772570e-05
		,7.0207652800e-05
		,7.7456968750e-05
		,8.5094508860e-05
		,9.3119147780e-05
		,1.0152992770e-04
		,1.1032614980e-04
		,1.1950761190e-04
		,1.2907375060e-04
		////////////////////////////////
		,1.5455875610e-17
		,2.1565545960e-12
		,3.6466939650e-12
		,4.6810509520e-12
		,5.4037254020e-12
		,5.9132386360e-12
		,6.2770747800e-12
		,6.5413429750e-12
		,6.7376262920e-12
		,6.8874430970e-12
		,7.0056169390e-12
		,7.1022138810e-12
		,7.1841636090e-12
		,7.2561392790e-12
		,7.3214594510e-12
		,7.3822439000e-12
		,7.4401181740e-12
		,7.4960138130e-12
		,7.5506534920e-12
		,7.6045900260e-12
		,7.6581427690e-12
		,7.7114803280e-12
		,7.7647767410e-12
		,7.8182057310e-12
		,7.8718142940e-12
		,7.9256938070e-12
		,7.9798007220e-12
		,8.0342536230e-12
		,8.0891074940e-12
		,8.1443847340e-12
		,8.2001398590e-12
		,8.2564175140e-12
		,8.3133504310e-12
		,8.3710421570e-12
		,8.4296161830e-12
		,8.4892185050e-12
		,8.5498847890e-12
		,8.6121419480e-12
		,8.6763681870e-12
		,8.7431892670e-12
		,8.8132388320e-12
		,8.8876107110e-12
		,8.9676854540e-12
		,9.0552593540e-12
		,9.1527208430e-12
		,9.2634704570e-12
		,9.3919239790e-12
		,9.5439691180e-12
		,9.7279260300e-12
		,9.9546123800e-12
		,1.0238803630e-11
		,1.0600516550e-11
		,1.1066891070e-11
		,1.1674473650e-11
		,1.2473039730e-11
		,1.3529726060e-11
		,1.4936099610e-11
		,1.6816248580e-11
		,1.9167251400e-11
		,2.2272356660e-11
		,2.6409855470e-11
		,3.1938760370e-11
		,3.9345372820e-11
		,4.9288670750e-11
		,6.2661859910e-11
		,8.0676419450e-11
		,1.0497942380e-10
		,1.3780743980e-10
		,1.8008027530e-10
		,2.3484029790e-10
		,3.0738251610e-10
		,4.0352296400e-10
		,5.3098784370e-10
		,7.0004325610e-10
		,9.2433140650e-10
		,1.2219830930e-09
		,1.6170952950e-09
		,2.1416955950e-09
		,2.8383499360e-09
		,3.7636203270e-09
		,4.9926671840e-09
		,6.6253366430e-09
		,8.7942194940e-09
		,1.1675318400e-08
		,1.5502133040e-08
		,2.0584228980e-08
		,2.7331664300e-08
		,3.6287043510e-08
		,4.8158773030e-08
		,6.3793402200e-08
		,8.4488573760e-08
		,1.1185118210e-07
		,1.4797884080e-07
		,1.9559746620e-07
		,2.5823025940e-07
		,3.4040108570e-07
		,4.4787302680e-07
		,5.8791900930e-07
		,7.6961551690e-07
		,1.0041423640e-06
		,1.3050616040e-06
		,1.6885384490e-06
		,2.1734587010e-06
		,2.7813940140e-06
		,3.5363725510e-06
		,4.4644308000e-06
		,5.5929527680e-06
		,6.9498410920e-06
		,8.5625855470e-06
		,1.0457353930e-05
		,1.2658191250e-05
		,1.5186422060e-05
		,1.8060225480e-05
		,2.1294597350e-05
		,2.4901355530e-05
		,2.8889385940e-05
		,3.3265062830e-05
		,3.8032636040e-05
		,4.3194645760e-05
		,4.8752313920e-05
		,5.4705912550e-05
		////////////////////////////////
		,-1.2897613020e-17
		,2.3523438420e-12
		,3.9789745030e-12
		,5.1088775250e-12
		,5.8990113470e-12
		,6.4566267190e-12
		,6.8552457530e-12
		,7.1451767790e-12
		,7.3607351420e-12
		,7.5255813850e-12
		,7.6558289570e-12
		,7.7624971830e-12
		,7.8530814100e-12
		,7.9328163800e-12
		,8.0052233060e-12
		,8.0726348480e-12
		,8.1368745060e-12
		,8.1989551220e-12
		,8.2596493940e-12
		,8.3195314390e-12
		,8.3790040570e-12
		,8.4382181510e-12
		,8.4974308350e-12
		,8.5567489960e-12
		,8.6162144600e-12
		,8.6758799640e-12
		,8.7358511430e-12
		,8.7960922290e-12
		,8.8566591450e-12
		,8.9175762760e-12
		,8.9788337010e-12
		,9.0404523590e-12
		,9.1024530840e-12
		,9.1648190620e-12
		,9.2275626170e-12
		,9.2907567470e-12
		,9.3544081360e-12
		,9.4185082720e-12
		,9.4831516680e-12
		,9.5483601490e-12
		,9.6141372140e-12
		,9.6806503210e-12
		,9.7478479320e-12
		,9.8159785460e-12
		,9.8851735380e-12
		,9.9557235970e-12
		,1.0027951420e-11
		,1.0102317290e-11
		,1.0179353930e-11
		,1.0259876900e-11
		,1.0344909740e-11
		,1.0435899530e-11
		,1.0534702880e-11
		,1.0643847680e-11
		,1.0766810390e-11
		,1.0908188240e-11
		,1.1074153690e-11
		,1.1273144320e-11
		,1.1516525920e-11
		,1.1819540540e-11
		,1.2202660550e-11
		,1.2694051630e-11
		,1.3331675740e-11
		,1.4166814220e-11
		,1.5207428300e-11
		,1.6536932830e-11
		,1.8285347630e-11
		,2.0596472340e-11
		,2.3664252240e-11
		,2.7750354100e-11
		,3.3209897970e-11
		,4.0523706780e-11
		,5.0343043260e-11
		,6.3551355010e-11
		,8.0990794990e-11
		,1.0304377190e-10
		,1.3216860180e-10
		,1.7066014970e-10
		,2.2156053200e-10
		,2.8890558530e-10
		,3.7805050370e-10
		,4.9610288640e-10
		,6.5249783650e-10
		,8.5976226810e-10
		,1.1345302380e-09
		,1.4988913580e-09
		,1.9821818920e-09
		,2.6233588860e-09
		,3.4741628570e-09
		,4.6032674970e-09
		,6.1018991490e-09
		,8.0911230280e-09
		,1.0731580170e-08
		,1.4236335450e-08
		,1.8887835990e-08
		,2.5060265220e-08
		,3.3243843530e-08
		,4.4001226840e-08
		,5.8245565440e-08
		,7.7091673570e-08
		,1.0200087590e-07
		,1.3488220410e-07
		,1.7821926980e-07
		,2.3522701260e-07
		,3.1004180590e-07
		,4.0794668160e-07
		,5.3563015220e-07
		,7.0147216160e-07
		,9.1584385460e-07
		,1.1913967680e-06
		,1.5433097700e-06
		,1.9894503260e-06
		,2.5504024260e-06
		,3.2493157230e-06
		,4.1115447500e-06
		,5.1640704770e-06
		,6.4347316270e-06
		,7.9513363550e-06
		,9.7407468530e-06
		,1.1828023170e-05
		,1.4235747520e-05
		////////////////////////////////
		,7.3623383420e-18
		,2.5554038520e-12
		,4.3279756110e-12
		,5.5628571370e-12
		,6.4286755050e-12
		,7.0413299070e-12
		,7.4802992450e-12
		,7.8003394830e-12
		,8.0388476710e-12
		,8.2216209430e-12
		,8.3662242050e-12
		,8.4848172920e-12
		,8.5856579630e-12
		,8.6744505930e-12
		,8.7550886980e-12
		,8.8302574000e-12
		,8.9017198350e-12
		,8.9708261640e-12
		,9.0384046410e-12
		,9.1050405090e-12
		,9.1711724890e-12
		,9.2370607750e-12
		,9.3028493800e-12
		,9.3687882110e-12
		,9.4348888610e-12
		,9.5012642730e-12
		,9.5678936660e-12
		,9.6348433540e-12
		,9.7021433100e-12
		,9.7698371860e-12
		,9.8378973070e-12
		,9.9062758440e-12
		,9.9751552400e-12
		,1.0044400410e-11
		,1.0114037940e-11
		,1.0184081650e-11
		,1.0254563000e-11
		,1.0325468650e-11
		,1.0396742580e-11
		,1.0468490120e-11
		,1.0540671630e-11
		,1.0613308620e-11
		,1.0686387310e-11
		,1.0759954320e-11
		,1.0834030290e-11
		,1.0908612600e-11
		,1.0983724340e-11
		,1.1059453270e-11
		,1.1135740390e-11
		,1.1212642360e-11
		,1.1290345230e-11
		,1.1368941150e-11
		,1.1448540730e-11
		,1.1529307860e-11
		,1.1611584770e-11
		,1.1695644090e-11
		,1.1781967150e-11
		,1.1871184090e-11
		,1.1964112420e-11
		,1.2061851590e-11
		,1.2165828590e-11
		,1.2278022920e-11
		,1.2401182330e-11
		,1.2538799570e-11
		,1.2695686260e-11
		,1.2878488200e-11
		,1.3095860030e-11
		,1.3359689510e-11
		,1.3685980620e-11
		,1.4096063860e-11
		,1.4599863740e-11
		,1.5213040360e-11
		,1.5999246510e-11
		,1.7016660490e-11
		,1.8343882650e-11
		,2.0086868710e-11
		,2.2388578710e-11
		,2.5442164790e-11
		,2.9508878410e-11
		,3.4940475290e-11
		,4.2216883290e-11
		,5.1315787960e-11
		,6.3208142140e-11
		,7.8864404800e-11
		,9.9494597630e-11
		,1.2670210700e-10
		,1.6261019550e-10
		,2.1003180600e-10
		,2.7269476730e-10
		,3.5553369090e-10
		,4.6509782970e-10
		,6.1007891510e-10
		,8.0200086030e-10
		,1.0561526630e-09
		,1.3928204550e-09
		,1.8389244890e-09
		,2.4301908330e-09
		,3.2140124490e-09
		,4.2533128360e-09
		,5.6315796950e-09
		,7.4595793840e-09
		,9.8842448960e-09
		,1.3100435400e-08
		,1.7366491120e-08
		,2.3022418510e-08
		,3.0436537330e-08
		,4.0253477100e-08
		,5.3244474610e-08
		,7.0423416040e-08
		,9.3119755140e-08
		,1.2307128410e-07
		,1.6254099620e-07
		,2.1446208910e-07
		,2.8261467100e-07
		,3.7183852060e-07
		,4.8827886400e-07
		,6.3966272810e-07
		,8.3559483460e-07
		,1.0878534760e-06
		,1.4106568380e-06
		,1.8208612170e-06
		////////////////////////////////
		,-2.6632045990e-18
		,2.7252856330e-12
		,4.6296933330e-12
		,5.9680999740e-12
		,6.9161499860e-12
		,7.5947027000e-12
		,8.0870329890e-12
		,8.4505610040e-12
		,8.7248725470e-12
		,8.9371908850e-12
		,9.1064201180e-12
		,9.2456548060e-12
		,9.3640547970e-12
		,9.4679043840e-12
		,9.5617413250e-12
		,9.6486484220e-12
		,9.7307400740e-12
		,9.8096010470e-12
		,9.8863661600e-12
		,9.9617185580e-12
		,1.0036240980e-11
		,1.0110213140e-11
		,1.0184002600e-11
		,1.0257763600e-11
		,1.0331629870e-11
		,1.0405642500e-11
		,1.0479990670e-11
		,1.0554616790e-11
		,1.0629618920e-11
		,1.0705016590e-11
		,1.0780798580e-11
		,1.0856987010e-11
		,1.0933612130e-11
		,1.1010664750e-11
		,1.1088237860e-11
		,1.1166174910e-11
		,1.1244587820e-11
		,1.1323543770e-11
		,1.1402892290e-11
		,1.1482755400e-11
		,1.1563064800e-11
		,1.1643898140e-11
		,1.1725194070e-11
		,1.1807014560e-11
		,1.1889282700e-11
		,1.1972117190e-11
		,1.2055369140e-11
		,1.2139169100e-11
		,1.2223458960e-11
		,1.2308307480e-11
		,1.2393659940e-11
		,1.2479589910e-11
		,1.2566066850e-11
		,1.2653133310e-11
		,1.2740728050e-11
		,1.2828996370e-11
		,1.2917845450e-11
		,1.3007489940e-11
		,1.3097828380e-11
		,1.3189085370e-11
		,1.3281317070e-11
		,1.3374614460e-11
		,1.3469302480e-11
		,1.3565609200e-11
		,1.3663808350e-11
		,1.3764531060e-11
		,1.3868316160e-11
		,1.3976117010e-11
		,1.4089031620e-11
		,1.4208587630e-11
		,1.4336983770e-11
		,1.4477005200e-11
		,1.4632443100e-11
		,1.4808382390e-11
		,1.5011811570e-11
		,1.5251976800e-11
		,1.5536669160e-11
		,1.5861980380e-11
		,1.6260180170e-11
		,1.6755290360e-11
		,1.7379727430e-11
		,1.8176979180e-11
		,1.9205573620e-11
		,2.0544436630e-11
		,2.2300185950e-11
		,2.4616215550e-11
		,2.7684725020e-11
		,3.1602445230e-11
		,3.6576071550e-11
		,4.3082980020e-11
		,5.1610797760e-11
		,6.2803941850e-11
		,7.7513558910e-11
		,9.6865294880e-11
		,1.2234789570e-10
		,1.5593089610e-10
		,2.0022091340e-10
		,2.5866834730e-10
		,3.3582864070e-10
		,4.3776253720e-10
		,5.7248829050e-10
		,7.5063204750e-10
		,9.8627948920e-10
		,1.2981035950e-09
		,1.7108659510e-09
		,2.2574064940e-09
		,2.9812780530e-09
		,3.9402468730e-09
		,5.2109329670e-09
		,6.8949364600e-09
		,9.1269389770e-09
		,1.2085777910e-08
		,1.6008277090e-08
		,2.1130648110e-08
		,2.7910567510e-08
		,3.6880943670e-08
		,4.8743697270e-08
		,6.4421576900e-08
		,8.5124723410e-08
		,1.1243565720e-07
		,1.4841691440e-07
		////////////////////////////////
		,6.6835255370e-18
		,2.8437364300e-12
		,4.8425254800e-12
		,6.2582863900e-12
		,7.2716035220e-12
		,8.0070722350e-12
		,8.5505420360e-12
		,8.9611356930e-12
		,9.2795137800e-12
		,9.5336385790e-12
		,9.7427979310e-12
		,9.9201339640e-12
		,1.0074696350e-11
		,1.0212707710e-11
		,1.0338375700e-11
		,1.0454718110e-11
		,1.0563751000e-11
		,1.0667039730e-11
		,1.0765730080e-11
		,1.0860735990e-11
		,1.0952837730e-11
		,1.1042623780e-11
		,1.1130633580e-11
		,1.1217385490e-11
		,1.1303243040e-11
		,1.1388498380e-11
		,1.1473374670e-11
		,1.1558213120e-11
		,1.1642982840e-11
		,1.1727877360e-11
		,1.1813026860e-11
		,1.1898500200e-11
		,1.1984308610e-11
		,1.2070496530e-11
		,1.2157153150e-11
		,1.2244228230e-11
		,1.2331793770e-11
		,1.2419808280e-11
		,1.2508431410e-11
		,1.2597549560e-11
		,1.2687160530e-11
		,1.2777303940e-11
		,1.2868017350e-11
		,1.2959279970e-11
		,1.3051067630e-11
		,1.3143451390e-11
		,1.3236421180e-11
		,1.3329894590e-11
		,1.3423994650e-11
		,1.3518616760e-11
		,1.3613898380e-11
		,1.3709678290e-11
		,1.3806077330e-11
		,1.3903104220e-11
		,1.4000697760e-11
		,1.4098921920e-11
		,1.4197685690e-11
		,1.4297137980e-11
		,1.4397149190e-11
		,1.4497853000e-11
		,1.4599162470e-11
		,1.4701107940e-11
		,1.4803760780e-11
		,1.4907017130e-11
		,1.5011081540e-11
		,1.5115856760e-11
		,1.5221461190e-11
		,1.5327975160e-11
		,1.5435411960e-11
		,1.5543955120e-11
		,1.5653775960e-11
		,1.5765089930e-11
		,1.5878094300e-11
		,1.5993231450e-11
		,1.6111119350e-11
		,1.6232175490e-11
		,1.6357562810e-11
		,1.6488397450e-11
		,1.6626371010e-11
		,1.6773779650e-11
		,1.6933509160e-11
		,1.7109565680e-11
		,1.7307471000e-11
		,1.7520974070e-11
		,1.7765287830e-11
		,1.8051102750e-11
		,1.8391833880e-11
		,1.8805757890e-11
		,1.9317124710e-11
		,1.9958830630e-11
		,2.0775009030e-11
		,2.1825333370e-11
		,2.3187711340e-11
		,2.4949167330e-11
		,2.7109540620e-11
		,2.9904440280e-11
		,3.3533251130e-11
		,3.8258840610e-11
		,4.4427426220e-11
		,5.2495678550e-11
		,6.3066398190e-11
		,7.6935094280e-11
		,9.5146761370e-11
		,1.1908242530e-10
		,1.5057770590e-10
		,1.9205302360e-10
		,2.4671129050e-10
		,3.1878808190e-10
		,4.1388864820e-10
		,5.3943262560e-10
		,7.0524398210e-10
		,9.2433474760e-10
		,1.2139423650e-09
		,1.5969068780e-09
		,2.1034982030e-09
		,2.7738404430e-09
		,3.6611292970e-09
		,4.8358077370e-09
		,6.3914591510e-09
		,8.4521890490e-09
		,1.1182698520e-08
		////////////////////////////////
		,1.6707540650e-18
		,1.8615448850e-14
		,3.1812614070e-14
		,4.1220541790e-14
		,4.8022298300e-14
		,5.3014287650e-14
		,5.6758566860e-14
		,5.9611408200e-14
		,6.1880940490e-14
		,6.3724126110e-14
		,6.5303096910e-14
		,6.6665421990e-14
		,6.7880757990e-14
		,6.8979442620e-14
		,7.0037764000e-14
		,7.1028674040e-14
		,7.1969351940e-14
		,7.2890970860e-14
		,7.3766848240e-14
		,7.4615259810e-14
		,7.5421219470e-14
		,7.6241695290e-14
		,7.7065095220e-14
		,7.7852256990e-14
		,7.8554514940e-14
		,7.9326272880e-14
		,8.0018818590e-14
		,8.0712251980e-14
		,8.1447928410e-14
		,8.2136453450e-14
		,8.2796259500e-14
		,8.3456117760e-14
		,8.4108404650e-14
		,8.4799227220e-14
		,8.5458458880e-14
		,8.6149908050e-14
		,8.6790185170e-14
		,8.7471713220e-14
		,8.8126140980e-14
		,8.8853201710e-14
		,8.9515096410e-14
		,9.0204404700e-14
		,9.0864941780e-14
		,9.1599365010e-14
		,9.2273530560e-14
		,9.2997980470e-14
		,9.3709689590e-14
		,9.4402078650e-14
		,9.5141827950e-14
		,9.5863928130e-14
		,9.6590884420e-14
		,9.7312775730e-14
		,9.8062498360e-14
		,9.8801359990e-14
		,9.9550299380e-14
		,1.0030273730e-13
		,1.0106828150e-13
		,1.0184124040e-13
		,1.0263216170e-13
		,1.0338841140e-13
		,1.0425327110e-13
		,1.0505886530e-13
		,1.0590012320e-13
		,1.0676707160e-13
		,1.0761203690e-13
		,1.0851203820e-13
		,1.0942253510e-13
		,1.1043506270e-13
		,1.1146429950e-13
		,1.1255316750e-13
		,1.1373894900e-13
		,1.1503563810e-13
		,1.1652260370e-13
		,1.1812042460e-13
		,1.2008981720e-13
		,1.2236117700e-13
		,1.2511961120e-13
		,1.2849910680e-13
		,1.3260550660e-13
		,1.3785126750e-13
		,1.4454206420e-13
		,1.5310920390e-13
		,1.6430434130e-13
		,1.7897526140e-13
		,1.9783957360e-13
		,2.1959635940e-13
		,2.4703929900e-13
		,2.8248131640e-13
		,3.2846895180e-13
		,3.8834561940e-13
		,4.6667403760e-13
		,5.6945861910e-13
		,7.0503685590e-13
		,8.8453798850e-13
		,1.1229653460e-12
		,1.4376993040e-12
		,1.8233485230e-12
		,2.3251378600e-12
		,2.9786514150e-12
		,3.8305013820e-12
		,4.9417657190e-12
		,6.3897241300e-12
		,8.2752993710e-12
		,1.0738421810e-11
		,1.3959657940e-11
		,1.8175476340e-11
		,2.3696533910e-11
		,3.0931673020e-11
		,4.0419329240e-11
		,5.2868292840e-11
		,6.9212471710e-11
		,9.0682938400e-11
		,1.1890323860e-10
		,1.5601522150e-10
		,2.0484587360e-10
		,2.6909793270e-10
		,3.5369405570e-10
		,4.6515438500e-10
		,6.1208027560e-10
		,8.0584632010e-10
		,1.0615014210e-09
		////////////////////////////////
		,-9.0858180460e-18
		,2.9952105310e-12
		,5.1123263640e-12
		,6.6232568300e-12
		,7.7157938700e-12
		,8.5197090530e-12
		,9.1247015390e-12
		,9.5925428730e-12
		,9.9660821760e-12
		,1.0274657160e-11
		,1.0538706360e-11
		,1.0772087160e-11
		,1.0984509200e-11
		,1.1182492270e-11
		,1.1370547900e-11
		,1.1551757870e-11
		,1.1728124610e-11
		,1.1901023820e-11
		,1.2071296910e-11
		,1.2239540760e-11
		,1.2406013080e-11
		,1.2570867990e-11
		,1.2734152540e-11
		,1.2895714170e-11
		,1.3055534120e-11
		,1.3213389680e-11
		,1.3369145840e-11
		,1.3522530380e-11
		,1.3673383630e-11
		,1.3821477450e-11
		,1.3966623240e-11
		,1.4108726070e-11
		,1.4247597700e-11
		,1.4383292790e-11
		,1.4515850580e-11
		,1.4645369890e-11
		,1.4772137500e-11
		,1.4896448900e-11
		,1.5018648470e-11
		,1.5139097070e-11
		,1.5258250490e-11
		,1.5376421460e-11
		,1.5494024160e-11
		,1.5611254610e-11
		,1.5728391070e-11
		,1.5845582980e-11
		,1.5963016130e-11
		,1.6080761020e-11
		,1.6198900030e-11
		,1.6317569250e-11
		,1.6436675570e-11
		,1.6556390010e-11
		,1.6676632560e-11
		,1.6797417690e-11
		,1.6918788950e-11
		,1.7040698970e-11
		,1.7163141300e-11
		,1.7286082440e-11
		,1.7409491340e-11
		,1.7533281310e-11
		,1.7657526720e-11
		,1.7782200710e-11
		,1.7907179030e-11
		,1.8032554030e-11
		,1.8158248390e-11
		,1.8284341000e-11
		,1.8410854790e-11
		,1.8537695920e-11
		,1.8664999790e-11
		,1.8792769280e-11
		,1.8921035290e-11
		,1.9049750680e-11
		,1.9179028910e-11
		,1.9308885960e-11
		,1.9439305110e-11
		,1.9570364590e-11
		,1.9702041640e-11
		,1.9834429880e-11
		,1.9967439590e-11
		,2.0101206440e-11
		,2.0235701760e-11
		,2.0371038920e-11
		,2.0507166470e-11
		,2.0644201130e-11
		,2.0782193170e-11
		,2.0921233510e-11
		,2.1061382030e-11
		,2.1202926040e-11
		,2.1345878480e-11
		,2.1490676620e-11
		,2.1637588050e-11
		,2.1787129100e-11
		,2.1939818380e-11
		,2.2096735940e-11
		,2.2258860140e-11
		,2.2425920150e-11
		,2.2598013400e-11
		,2.2778649970e-11
		,2.2970410940e-11
		,2.3176492760e-11
		,2.3401399210e-11
		,2.3650961400e-11
		,2.3933174630e-11
		,2.4258832150e-11
		,2.4642335640e-11
		,2.5103621790e-11
		,2.5653456290e-11
		,2.6303548940e-11
		,2.7104379810e-11
		,2.8101984620e-11
		,2.9356669620e-11
		,3.0941756840e-11
		,3.2962241580e-11
		,3.5553020770e-11
		,3.8892843830e-11
		,4.3214847350e-11
		,4.8825620840e-11
		,5.6128594180e-11
		,6.5654766500e-11
		,7.8103243700e-11
		,9.4395438980e-11
		////////////////////////////////
		,1.2114027960e-17
		,3.0498586170e-12
		,5.2089093120e-12
		,6.7527192240e-12
		,7.8719075520e-12
		,8.6981865880e-12
		,9.3226847070e-12
		,9.8082532390e-12
		,1.0198344090e-11
		,1.0523022390e-11
		,1.0802990270e-11
		,1.1052587290e-11
		,1.1281657100e-11
		,1.1496963160e-11
		,1.1703255000e-11
		,1.1903640430e-11
		,1.2100306960e-11
		,1.2294712270e-11
		,1.2487785170e-11
		,1.2680191100e-11
		,1.2872282960e-11
		,1.3064317380e-11
		,1.3256332900e-11
		,1.3448356350e-11
		,1.3640368890e-11
		,1.3832314020e-11
		,1.4023970910e-11
		,1.4215241300e-11
		,1.4405903940e-11
		,1.4595823600e-11
		,1.4784744360e-11
		,1.4972423200e-11
		,1.5158634030e-11
		,1.5343077500e-11
		,1.5525502220e-11
		,1.5705634180e-11
		,1.5883158400e-11
		,1.6057855110e-11
		,1.6229402900e-11
		,1.6397583110e-11
		,1.6562261530e-11
		,1.6723212740e-11
		,1.6880462440e-11
		,1.7033993140e-11
		,1.7183954170e-11
		,1.7330549950e-11
		,1.7474099070e-11
		,1.7614966150e-11
		,1.7753565940e-11
		,1.7890338520e-11
		,1.8025661680e-11
		,1.8159954190e-11
		,1.8293475520e-11
		,1.8426520640e-11
		,1.8559370360e-11
		,1.8692120820e-11
		,1.8825047560e-11
		,1.8958166880e-11
		,1.9091626750e-11
		,1.9225578810e-11
		,1.9360006360e-11
		,1.9495029060e-11
		,1.9630623540e-11
		,1.9766977710e-11
		,1.9903903390e-11
		,2.0041563700e-11
		,2.0179993270e-11
		,2.0319161540e-11
		,2.0459105370e-11
		,2.0599762590e-11
		,2.0741260650e-11
		,2.0883571720e-11
		,2.1026655690e-11
		,2.1170565420e-11
		,2.1315270920e-11
		,2.1460815900e-11
		,2.1607205170e-11
		,2.1754392360e-11
		,2.1902405200e-11
		,2.2051277980e-11
		,2.2200987430e-11
		,2.2351519810e-11
		,2.2502895950e-11
		,2.2655202380e-11
		,2.2808311220e-11
		,2.2962279390e-11
		,2.3117213340e-11
		,2.3272980460e-11
		,2.3429693750e-11
		,2.3587340920e-11
		,2.3745952740e-11
		,2.3905568050e-11
		,2.4066289040e-11
		,2.4228111800e-11
		,2.4391146600e-11
		,2.4555520030e-11
		,2.4721437020e-11
		,2.4889120700e-11
		,2.5058728450e-11
		,2.5230756950e-11
		,2.5405703040e-11
		,2.5583963150e-11
		,2.5764799610e-11
		,2.5950149970e-11
		,2.6141124550e-11
		,2.6339091110e-11
		,2.6546064740e-11
		,2.6764589980e-11
		,2.6998224610e-11
		,2.7251298920e-11
		,2.7529354010e-11
		,2.7841361700e-11
		,2.8197668240e-11
		,2.8594522100e-11
		,2.9057116630e-11
		,2.9605051140e-11
		,3.0263941210e-11
		,3.1067214860e-11
		,3.2058276120e-11
		,3.3294729570e-11
		,3.4851522610e-11
		////////////////////////////////
		,7.2579056000e-18
		,3.0965818760e-12
		,5.2912266430e-12
		,6.8629121080e-12
		,8.0044711290e-12
		,8.8494085890e-12
		,9.4898812610e-12
		,9.9896684140e-12
		,1.0392991460e-11
		,1.0730238510e-11
		,1.1022546110e-11
		,1.1284480230e-11
		,1.1526050390e-11
		,1.1754242350e-11
		,1.1973868470e-11
		,1.2188170770e-11
		,1.2399525770e-11
		,1.2609351870e-11
		,1.2818754080e-11
		,1.3028523480e-11
		,1.3239043220e-11
		,1.3450586930e-11
		,1.3663367540e-11
		,1.3877480550e-11
		,1.4092935680e-11
		,1.4309650950e-11
		,1.4527569130e-11
		,1.4746643170e-11
		,1.4966690730e-11
		,1.5187543050e-11
		,1.5409053770e-11
		,1.5631112020e-11
		,1.5853416480e-11
		,1.6075804590e-11
		,1.6298035580e-11
		,1.6519821370e-11
		,1.6740859580e-11
		,1.6960760460e-11
		,1.7179169420e-11
		,1.7395685380e-11
		,1.7609879750e-11
		,1.7821306130e-11
		,1.8029710480e-11
		,1.8234792830e-11
		,1.8436381750e-11
		,1.8634371190e-11
		,1.8828575250e-11
		,1.9019008290e-11
		,1.9205497540e-11
		,1.9388029730e-11
		,1.9566597600e-11
		,1.9741243920e-11
		,1.9912099740e-11
		,2.0079348200e-11
		,2.0243350470e-11
		,2.0404464390e-11
		,2.0563141010e-11
		,2.0719870900e-11
		,2.0875091050e-11
		,2.1029229600e-11
		,2.1182725410e-11
		,2.1335943380e-11
		,2.1489107200e-11
		,2.1642421250e-11
		,2.1796123690e-11
		,2.1950277950e-11
		,2.2105097030e-11
		,2.2260602080e-11
		,2.2416870890e-11
		,2.2573935540e-11
		,2.2731840190e-11
		,2.2890629960e-11
		,2.3050280990e-11
		,2.3210868410e-11
		,2.3372380380e-11
		,2.3534827330e-11
		,2.3698225930e-11
		,2.3862591310e-11
		,2.4027877160e-11
		,2.4194153880e-11
		,2.4361413920e-11
		,2.4529571680e-11
		,2.4698756680e-11
		,2.4868875320e-11
		,2.5039985330e-11
		,2.5212070430e-11
		,2.5385114120e-11
		,2.5559138280e-11
		,2.5734135490e-11
		,2.5910106590e-11
		,2.6087057160e-11
		,2.6265048720e-11
		,2.6443973330e-11
		,2.6624010670e-11
		,2.6804964050e-11
		,2.6986978040e-11
		,2.7170095890e-11
		,2.7354220880e-11
		,2.7539477360e-11
		,2.7725879400e-11
		,2.7913419610e-11
		,2.8102233270e-11
		,2.8292353960e-11
		,2.8483907940e-11
		,2.8677014520e-11
		,2.8871946890e-11
		,2.9068823180e-11
		,2.9267938450e-11
		,2.9468793990e-11
		,2.9672390940e-11
		,2.9879157690e-11
		,3.0089858570e-11
		,3.0305217830e-11
		,3.0526333740e-11
		,3.0754843170e-11
		,3.0992614270e-11
		,3.1242375560e-11
		,3.1507695180e-11
		,3.1793497360e-11
		,3.2100973450e-11
		,3.2437012310e-11
		////////////////////////////////
		,1.8118910460e-17
		,6.9323501670e-12
		,1.2210798210e-11
		,1.6313237070e-11
		,1.9582470280e-11
		,2.2265042610e-11
		,2.4538844830e-11
		,2.6532112530e-11
		,2.8337313350e-11
		,3.0020895730e-11
		,3.1630962840e-11
		,3.3202141750e-11
		,3.4761629310e-11
		,3.6331372020e-11
		,3.7929264510e-11
		,3.9576656870e-11
		,4.1295251520e-11
		,4.3110177650e-11
		,4.5052909560e-11
		,4.7164496510e-11
		,4.9500538200e-11
		,5.2137240110e-11
		,5.5178899190e-11
		,5.8769492050e-11
		,6.3114165100e-11
		,6.8475893400e-11
		,7.5227203930e-11
		,8.3860754330e-11
		,9.5075899320e-11
		,1.0983776280e-10
		,1.2937167850e-10
		,1.5540122690e-10
		,1.9039209250e-10
		,2.3764963500e-10
		,3.0169345910e-10
		,3.8702962830e-10
		,5.0148244200e-10
		,6.5669314900e-10
		,8.6748015550e-10
		,1.1540745740e-09
		,1.5440935820e-09
		,2.0751999240e-09
		,2.7990255210e-09
		,3.7860427960e-09
		,5.1325351250e-09
		,6.8641212700e-09
		,9.1797478290e-09
		,1.2284219150e-08
		,1.6445223930e-08
		,2.2020343650e-08
		,2.9486593800e-08
		,3.9479253210e-08
		,5.2842632990e-08
		,7.0696019880e-08
		,9.4518630440e-08
		,1.2625794730e-07
		,1.6846613000e-07
		,2.2444535890e-07
		,2.9839168030e-07
		,3.9588488410e-07
		,5.2390977490e-07
		,6.9123195900e-07
		,9.0870391580e-07
		,1.1895378820e-06
		,1.5495178520e-06
		,2.0071086720e-06
		,2.5833459990e-06
		,3.3016197960e-06
		,4.1870388990e-06
		,5.2659300500e-06
		,6.5644390040e-06
		,8.1086721160e-06
		,9.9221334390e-06
		,1.2026668470e-05
		,1.4441884940e-05
		,1.7183504620e-05
		,2.0258041170e-05
		,2.3676195310e-05
		,2.7447651220e-05
		,3.1568276590e-05
		,3.6026416930e-05
		,4.0835212610e-05
		,4.5994988570e-05
		,5.1504487050e-05
		,5.7307124420e-05
		,6.3414477680e-05
		,6.9849213620e-05
		,7.6610708800e-05
		,8.3699791740e-05
		,9.1119116650e-05
		,9.8873517570e-05
		,1.0697047320e-04
		,1.1542034850e-04
		,1.2423657080e-04
		,1.3343539810e-04
		,1.4277188600e-04
		,1.5214726610e-04
		,1.6181598220e-04
		,1.7177113510e-04
		,1.8200748630e-04
		,1.9236800910e-04
		,2.0276808560e-04
		,2.1342266470e-04
		,2.2432739790e-04
		,2.3547864910e-04
		,2.4687354320e-04
		,2.5851010360e-04
		,2.7009195960e-04
		,2.8157068890e-04
		,2.9306532060e-04
		,3.0467188270e-04
		,3.1642388640e-04
		,3.2833135470e-04
		,3.4038782800e-04
		,3.5258875820e-04
		,3.6492948330e-04
		,3.7741683500e-04
		,3.9004386870e-04
		,4.0280258200e-04
		,4.1568959090e-04
		,4.2870218800e-04
		////////////////////////////////
		,1.9737617910e-17
		,1.6545783560e-11
		,2.8401119360e-11
		,3.6998824210e-11
		,4.3336889900e-11
		,4.8108241860e-11
		,5.1792694160e-11
		,5.4721140530e-11
		,5.7121589170e-11
		,5.9151215900e-11
		,6.0918664870e-11
		,6.2498099400e-11
		,6.3940253130e-11
		,6.5280352620e-11
		,6.6544151420e-11
		,6.7750837670e-11
		,6.8914827800e-11
		,7.0048198090e-11
		,7.1161685230e-11
		,7.2265169540e-11
		,7.3366961090e-11
		,7.4478807170e-11
		,7.5612432590e-11
		,7.6781659190e-11
		,7.8003572940e-11
		,7.9300452000e-11
		,8.0701730760e-11
		,8.2247147730e-11
		,8.3990400630e-11
		,8.6004261770e-11
		,8.8388100600e-11
		,9.1277082150e-11
		,9.4855320400e-11
		,9.9372292640e-11
		,1.0517218200e-10
		,1.1272167040e-10
		,1.2265619960e-10
		,1.3583644560e-10
		,1.5343570480e-10
		,1.7706426590e-10
		,2.0890479050e-10
		,2.5115262170e-10
		,3.0681698470e-10
		,3.8184680090e-10
		,4.8312508320e-10
		,6.2014728220e-10
		,8.0578692530e-10
		,1.0574881960e-09
		,1.3991805190e-09
		,1.8633870270e-09
		,2.4944274690e-09
		,3.3156352950e-09
		,4.3823553150e-09
		,5.8033601550e-09
		,7.6963859880e-09
		,1.0218148790e-08
		,1.3577123120e-08
		,1.8050420810e-08
		,2.4006028730e-08
		,3.1932011330e-08
		,4.2474708060e-08
		,5.6488449190e-08
		,7.5099867950e-08
		,9.9790468350e-08
		,1.3250164790e-07
		,1.7574617070e-07
		,2.3267867990e-07
		,3.0761228250e-07
		,4.0593710200e-07
		,5.3448408660e-07
		,7.0181623450e-07
		,9.1853095930e-07
		,1.1975494040e-06
		,1.5543559940e-06
		,2.0071433070e-06
		,2.5768116380e-06
		,3.2867805500e-06
		,4.1625481510e-06
		,5.2310869890e-06
		,6.5199795290e-06
		,8.0564548630e-06
		,9.8665090490e-06
		,1.1974068000e-05
		,1.4399910430e-05
		,1.7162267060e-05
		,2.0275113740e-05
		,2.3745076710e-05
		,2.7580044430e-05
		,3.1786556570e-05
		,3.6366995120e-05
		,4.1321777030e-05
		,4.6649890980e-05
		,5.2343220230e-05
		,5.8396882500e-05
		,6.4811141090e-05
		,7.1581540420e-05
		,7.8703387680e-05
		,8.6171854400e-05
		,9.3982032030e-05
		,1.0212897120e-04
		,1.1060774620e-04
		,1.1941339620e-04
		,1.2854088090e-04
		,1.3798514770e-04
		,1.4774114090e-04
		,1.5778502910e-04
		,1.6811724800e-04
		,1.7833226160e-04
		,1.8879052170e-04
		,1.9950860860e-04
		,2.1047775510e-04
		,2.2168934510e-04
		,2.3312955830e-04
		,2.4479183970e-04
		,2.5666412870e-04
		,2.6874071680e-04
		,2.8102420080e-04
		,2.9349882980e-04
		,3.0605700180e-04
		,3.1878875510e-04
		,3.3169152280e-04
		////////////////////////////////
		,-1.7022706200e-17
		,2.3405076440e-11
		,3.9779744500e-11
		,5.1302251280e-11
		,5.9477667840e-11
		,6.5346397190e-11
		,6.9626431700e-11
		,7.2812432330e-11
		,7.5244680480e-11
		,7.7156672770e-11
		,7.8707872860e-11
		,8.0006758030e-11
		,8.1127172300e-11
		,8.2119644030e-11
		,8.3019371500e-11
		,8.3851434120e-11
		,8.4635382080e-11
		,8.5386790830e-11
		,8.6116903760e-11
		,8.6833597870e-11
		,8.7542361250e-11
		,8.8247220780e-11
		,8.8951095930e-11
		,8.9656301180e-11
		,9.0364879460e-11
		,9.1078810640e-11
		,9.1798958030e-11
		,9.2528608430e-11
		,9.3271082020e-11
		,9.4030908470e-11
		,9.4814742690e-11
		,9.5631564460e-11
		,9.6494026050e-11
		,9.7418991620e-11
		,9.8429117550e-11
		,9.9554671940e-11
		,1.0083634980e-10
		,1.0232893820e-10
		,1.0410686610e-10
		,1.0627073910e-10
		,1.0895747310e-10
		,1.1235302160e-10
		,1.1671072380e-10
		,1.2237604400e-10
		,1.2982073140e-10
		,1.3968842600e-10
		,1.5285575050e-10
		,1.7035860830e-10
		,1.9292838200e-10
		,2.2316180460e-10
		,2.6378727500e-10
		,3.1851521000e-10
		,3.9238643850e-10
		,4.9227257710e-10
		,6.2751318210e-10
		,8.1083584110e-10
		,1.0595722310e-09
		,1.3920768660e-09
		,1.8141484660e-09
		,2.3755769530e-09
		,3.1225418630e-09
		,4.1165192990e-09
		,5.4393288820e-09
		,7.1998315230e-09
		,9.5428041280e-09
		,1.2660681430e-08
		,1.6809062770e-08
		,2.2327142210e-08
		,2.9664546340e-08
		,3.9416462980e-08
		,5.2369420780e-08
		,6.9551971810e-08
		,9.2328743880e-08
		,1.2247510250e-07
		,1.6219229340e-07
		,2.1458283100e-07
		,2.8352887060e-07
		,3.7400584270e-07
		,4.9233580730e-07
		,6.4647047610e-07
		,8.4629194170e-07
		,1.1039101640e-06
		,1.4339258820e-06
		,1.8536174580e-06
		,2.3830024210e-06
		,3.0447247070e-06
		,3.8637292670e-06
		,4.8667078880e-06
		,6.0813398180e-06
		,7.5353800260e-06
		,9.2556963210e-06
		,1.1267368650e-05
		,1.3592916270e-05
		,1.6251746320e-05
		,1.9259959840e-05
		,2.2630241470e-05
		,2.6372033390e-05
		,3.0491937070e-05
		,3.4994056750e-05
		,3.9880446700e-05
		,4.5151533200e-05
		,5.0806508460e-05
		,5.6843662680e-05
		,6.3260652270e-05
		,7.0054718450e-05
		,7.7222850270e-05
		,8.4761900950e-05
		,9.2668659830e-05
		,1.0093987500e-04
		,1.0957235310e-04
		,1.1856287510e-04
		,1.2790815620e-04
		,1.3760486760e-04
		,1.4764968030e-04
		,1.5774976010e-04
		,1.6799200980e-04
		,1.7854568950e-04
		,1.8940311180e-04
		,2.0055797820e-04
		,2.1200301130e-04
		,2.2373168630e-04
		////////////////////////////////
		,-1.2845396640e-17
		,2.7031900510e-11
		,4.5756099730e-11
		,5.8786827310e-11
		,6.7917082220e-11
		,7.4375865990e-11
		,7.9005740050e-11
		,8.2383639700e-11
		,8.4904676460e-11
		,8.6839513410e-11
		,8.8373536150e-11
		,8.9633604810e-11
		,9.0706655650e-11
		,9.1652189980e-11
		,9.2511010260e-11
		,9.3311003680e-11
		,9.4071331660e-11
		,9.4804943410e-11
		,9.5520930350e-11
		,9.6225412400e-11
		,9.6922645730e-11
		,9.7615664830e-11
		,9.8306520610e-11
		,9.8996631990e-11
		,9.9687217970e-11
		,1.0037888330e-10
		,1.0107238370e-10
		,1.0176823870e-10
		,1.0246678290e-10
		,1.0316859960e-10
		,1.0387415530e-10
		,1.0458408240e-10
		,1.0529837820e-10
		,1.0601839120e-10
		,1.0674526310e-10
		,1.0748015620e-10
		,1.0822425360e-10
		,1.0897895000e-10
		,1.0974755500e-10
		,1.1053734490e-10
		,1.1136003190e-10
		,1.1223029230e-10
		,1.1316618270e-10
		,1.1419049350e-10
		,1.1533376860e-10
		,1.1663683540e-10
		,1.1815482260e-10
		,1.1996244120e-10
		,1.2216130340e-10
		,1.2488968890e-10
		,1.2833503810e-10
		,1.3275240050e-10
		,1.3848860570e-10
		,1.4601580820e-10
		,1.5545886320e-10
		,1.6787173460e-10
		,1.8433824950e-10
		,2.0629092790e-10
		,2.3567569120e-10
		,2.7513709090e-10
		,3.2827118150e-10
		,3.9996995620e-10
		,4.9689067600e-10
		,6.2809591590e-10
		,7.9465734780e-10
		,1.0135973900e-09
		,1.3043456670e-09
		,1.6906074850e-09
		,2.2039202970e-09
		,2.8862669180e-09
		,3.7935103120e-09
		,4.9999514380e-09
		,6.6043978050e-09
		,8.7381986020e-09
		,1.1575877120e-08
		,1.5349177950e-08
		,2.0365584440e-08
		,2.7032669660e-08
		,3.5890013940e-08
		,4.7650882150e-08
		,6.3256389380e-08
		,8.3938174980e-08
		,1.1119855920e-07
		,1.4723009050e-07
		,1.9477044540e-07
		,2.5736037730e-07
		,3.3954878500e-07
		,4.4713313330e-07
		,5.8743198900e-07
		,7.6958045230e-07
		,1.0048311030e-06
		,1.3068331290e-06
		,1.6918518620e-06
		,2.1788824280e-06
		,2.7896081020e-06
		,3.5481604540e-06
		,4.4806574240e-06
		,5.6145262900e-06
		,6.9776535730e-06
		,8.5974438670e-06
		,1.0499892000e-05
		,1.2708775320e-05
		,1.5245044720e-05
		,1.8126464720e-05
		,2.1367503290e-05
		,2.4979441240e-05
		,2.8970646270e-05
		,3.3346959800e-05
		,3.8112126610e-05
		,4.3268226430e-05
		,4.8816080810e-05
		,5.4755631340e-05
		,6.1086234480e-05
		,6.7806920730e-05
		,7.4916597760e-05
		,8.2414208190e-05
		,9.0298879100e-05
		,9.8569963260e-05
		,1.0722708480e-04
		,1.1627056370e-04
		,1.2565075120e-04
		////////////////////////////////
		,1.8275559570e-17
		,2.9917038620e-11
		,5.0604040570e-11
		,6.4973715490e-11
		,7.5019396200e-11
		,8.2104573390e-11
		,8.7161047560e-11
		,9.0825198970e-11
		,9.3534054930e-11
		,9.5589962320e-11
		,9.7201386270e-11
		,9.8510907130e-11
		,9.9615795900e-11
		,1.0058241720e-10
		,1.0145600440e-10
		,1.0226752540e-10
		,1.0303803980e-10
		,1.0378194100e-10
		,1.0450919330e-10
		,1.0522647530e-10
		,1.0593833680e-10
		,1.0664798220e-10
		,1.0735749480e-10
		,1.0806830760e-10
		,1.0878158130e-10
		,1.0949773990e-10
		,1.1021744900e-10
		,1.1094088870e-10
		,1.1166830240e-10
		,1.1239981170e-10
		,1.1313563200e-10
		,1.1387560610e-10
		,1.1461990040e-10
		,1.1536857760e-10
		,1.1612167570e-10
		,1.1687935440e-10
		,1.1764177460e-10
		,1.1840902720e-10
		,1.1918113960e-10
		,1.1995872440e-10
		,1.2074246990e-10
		,1.2153305650e-10
		,1.2233165400e-10
		,1.2313976420e-10
		,1.2395948650e-10
		,1.2479356770e-10
		,1.2564582190e-10
		,1.2652117840e-10
		,1.2742657090e-10
		,1.2837116980e-10
		,1.2936728000e-10
		,1.3043172280e-10
		,1.3158714630e-10
		,1.3286412400e-10
		,1.3430410830e-10
		,1.3596336490e-10
		,1.3791803560e-10
		,1.4027140000e-10
		,1.4316398270e-10
		,1.4678637240e-10
		,1.5121226850e-10
		,1.5677064180e-10
		,1.6394071220e-10
		,1.7328478720e-10
		,1.8556498390e-10
		,2.0181504280e-10
		,2.2343841580e-10
		,2.5234060070e-10
		,2.9111127610e-10
		,3.4327020410e-10
		,4.1112521770e-10
		,4.9810183860e-10
		,6.1319510490e-10
		,7.6563376270e-10
		,9.6768667790e-10
		,1.2356659050e-09
		,1.5912608370e-09
		,2.0633108050e-09
		,2.6901615480e-09
		,3.5227943360e-09
		,4.6289795410e-09
		,6.0987724280e-09
		,8.0518387080e-09
		,1.0647103000e-08
		,1.4095511130e-08
		,1.8676873670e-08
		,2.4762032180e-08
		,3.2841958180e-08
		,4.3565832900e-08
		,5.7787721760e-08
		,7.6520824420e-08
		,1.0130957580e-07
		,1.3406833050e-07
		,1.7728972210e-07
		,2.3420274560e-07
		,3.0896446390e-07
		,4.0688703160e-07
		,5.3469845590e-07
		,7.0083032850e-07
		,9.1571840980e-07
		,1.1920926000e-06
		,1.5452224440e-06
		,1.9930748620e-06
		,2.5563354170e-06
		,3.2582472440e-06
		,4.1242414680e-06
		,5.1813326760e-06
		,6.4573327520e-06
		,7.9799466740e-06
		,9.7758351830e-06
		,1.1869757050e-05
		,1.4283882120e-05
		,1.7037335520e-05
		,2.0145991020e-05
		,2.3622495300e-05
		,2.7476476590e-05
		,3.1714881030e-05
		,3.6342391980e-05
		,4.1361835340e-05
		,4.6774588970e-05
		,5.2580985430e-05
		////////////////////////////////
		,-3.1346797010e-19
		,3.2518136240e-11
		,5.4996641980e-11
		,7.0604233450e-11
		,8.1510661320e-11
		,8.9201181790e-11
		,9.4692513990e-11
		,9.8680402450e-11
		,1.0164091960e-10
		,1.0389988160e-10
		,1.0568016340e-10
		,1.0713420370e-10
		,1.0836638160e-10
		,1.0944814880e-10
		,1.1042827870e-10
		,1.1134020580e-10
		,1.1220674970e-10
		,1.1304353150e-10
		,1.1386134150e-10
		,1.1466735420e-10
		,1.1546660280e-10
		,1.1626246590e-10
		,1.1705729250e-10
		,1.1785260180e-10
		,1.1864941990e-10
		,1.1944847710e-10
		,1.2025020030e-10
		,1.2105505910e-10
		,1.2186319150e-10
		,1.2267480080e-10
		,1.2349003220e-10
		,1.2430898350e-10
		,1.2513181120e-10
		,1.2595857230e-10
		,1.2678943280e-10
		,1.2762438610e-10
		,1.2846357760e-10
		,1.2930707930e-10
		,1.3015496500e-10
		,1.3100733800e-10
		,1.3186432620e-10
		,1.3272597730e-10
		,1.3359241240e-10
		,1.3446383760e-10
		,1.3534015700e-10
		,1.3622184830e-10
		,1.3710907080e-10
		,1.3800229340e-10
		,1.3890198280e-10
		,1.3980881600e-10
		,1.4072367480e-10
		,1.4164768440e-10
		,1.4258254490e-10
		,1.4353030360e-10
		,1.4449389640e-10
		,1.4547703500e-10
		,1.4648497600e-10
		,1.4752467380e-10
		,1.4860564270e-10
		,1.4974056930e-10
		,1.5094657030e-10
		,1.5224701880e-10
		,1.5367327390e-10
		,1.5526780440e-10
		,1.5708838040e-10
		,1.5921342600e-10
		,1.6169007960e-10
		,1.6459754140e-10
		,1.6815730010e-10
		,1.7259259950e-10
		,1.7820531210e-10
		,1.8540473810e-10
		,1.9474441460e-10
		,2.0697535000e-10
		,2.2311594620e-10
		,2.4454834430e-10
		,2.7293214310e-10
		,3.0833274560e-10
		,3.5485884370e-10
		,4.1613309930e-10
		,4.9696243480e-10
		,6.0372869200e-10
		,7.4491216710e-10
		,9.3177421140e-10
		,1.1792737630e-09
		,1.5072837840e-09
		,1.9422073010e-09
		,2.5191231290e-09
		,3.2846351510e-09
		,4.3006536730e-09
		,5.6494078260e-09
		,7.4400887320e-09
		,9.8176422100e-09
		,1.2974392330e-08
		,1.7165387670e-08
		,2.2728630270e-08
		,3.0111646710e-08
		,3.9906467250e-08
		,5.2788356140e-08
		,6.9843885540e-08
		,9.2404044870e-08
		,1.2221007980e-07
		,1.6153149560e-07
		,2.1331236490e-07
		,2.8135000830e-07
		,3.7050853240e-07
		,4.8696705050e-07
		,6.3849798060e-07
		,8.3476429210e-07
		,1.0876159340e-06
		,1.4113555870e-06
		,1.8229340620e-06
		,2.3420278250e-06
		,2.9909526020e-06
		,3.7943744770e-06
		,4.7787958370e-06
		,5.9718413550e-06
		,7.4013969130e-06
		,9.0946804520e-06
		,1.1077352300e-05
		,1.3372761550e-05
		////////////////////////////////
		,2.3444980140e-17
		,3.5170464640e-11
		,5.9576113870e-11
		,7.6584626460e-11
		,8.8512036260e-11
		,9.6950961310e-11
		,1.0299604340e-10
		,1.0739926900e-10
		,1.1067703140e-10
		,1.1318374720e-10
		,1.1516275140e-10
		,1.1678078010e-10
		,1.1815237550e-10
		,1.1935593470e-10
		,1.2044538850e-10
		,1.2145761480e-10
		,1.2241801720e-10
		,1.2334403310e-10
		,1.2424765710e-10
		,1.2513717530e-10
		,1.2601832540e-10
		,1.2689500830e-10
		,1.2777003230e-10
		,1.2864536340e-10
		,1.2952229440e-10
		,1.3040180280e-10
		,1.3128449260e-10
		,1.3217097710e-10
		,1.3306152590e-10
		,1.3395642350e-10
		,1.3485583370e-10
		,1.3575991820e-10
		,1.3666878700e-10
		,1.3758255810e-10
		,1.3850125640e-10
		,1.3942497510e-10
		,1.4035367540e-10
		,1.4128752140e-10
		,1.4222643830e-10
		,1.4317048150e-10
		,1.4411967600e-10
		,1.4507413030e-10
		,1.4603370190e-10
		,1.4699854600e-10
		,1.4796862750e-10
		,1.4894405860e-10
		,1.4992475310e-10
		,1.5091078850e-10
		,1.5190227360e-10
		,1.5289920600e-10
		,1.5390160190e-10
		,1.5490957830e-10
		,1.5592327640e-10
		,1.5694287080e-10
		,1.5796856830e-10
		,1.5900071780e-10
		,1.6003961830e-10
		,1.6108580790e-10
		,1.6214001960e-10
		,1.6320308080e-10
		,1.6427630990e-10
		,1.6536133350e-10
		,1.6646037920e-10
		,1.6757640000e-10
		,1.6871346260e-10
		,1.6987689670e-10
		,1.7107395880e-10
		,1.7231443820e-10
		,1.7361162210e-10
		,1.7498325630e-10
		,1.7645378170e-10
		,1.7805563470e-10
		,1.7981974620e-10
		,1.8174794370e-10
		,1.8394603250e-10
		,1.8650446900e-10
		,1.8954479150e-10
		,1.9323091350e-10
		,1.9778442980e-10
		,2.0350485790e-10
		,2.1079754940e-10
		,2.2021190540e-10
		,2.3249288360e-10
		,2.4780341610e-10
		,2.6734632970e-10
		,2.9278094480e-10
		,3.2601016270e-10
		,3.6955595150e-10
		,4.2676194580e-10
		,5.0206210490e-10
		,6.0133799580e-10
		,7.3238547980e-10
		,9.0556140740e-10
		,1.1346077920e-09
		,1.4377644510e-09
		,1.8392447470e-09
		,2.3711940200e-09
		,3.0762882330e-09
		,4.0111813480e-09
		,5.2510767540e-09
		,6.8957841050e-09
		,9.0777417320e-09
		,1.1972627340e-08
		,1.5813381200e-08
		,2.0908692520e-08
		,2.7667455970e-08
		,3.6539675570e-08
		,4.8284655010e-08
		,6.3826554710e-08
		,8.4375396760e-08
		,1.1151528290e-07
		,1.4731262960e-07
		,1.9445129110e-07
		,2.5639863170e-07
		,3.3760564180e-07
		,4.4374207730e-07
		,5.8196388760e-07
		,7.6120450340e-07
		,9.9247364100e-07
		,1.2891377930e-06
		,1.6671464460e-06
		////////////////////////////////
		,-1.0756741870e-17
		,3.7311339130e-11
		,6.3402133830e-11
		,8.1752944910e-11
		,9.4762069430e-11
		,1.0408167600e-10
		,1.1084980030e-10
		,1.1585065470e-10
		,1.1962492220e-10
		,1.2254569610e-10
		,1.2487126600e-10
		,1.2678089800e-10
		,1.2839940030e-10
		,1.2981415680e-10
		,1.3108647520e-10
		,1.3225949620e-10
		,1.3336380000e-10
		,1.3442082850e-10
		,1.3544579910e-10
		,1.3644954510e-10
		,1.3743962070e-10
		,1.3842145200e-10
		,1.3939889960e-10
		,1.4037465880e-10
		,1.4135074500e-10
		,1.4232854580e-10
		,1.4330908590e-10
		,1.4429312800e-10
		,1.4528115980e-10
		,1.4627370930e-10
		,1.4727097680e-10
		,1.4827323650e-10
		,1.4928067500e-10
		,1.5029344300e-10
		,1.5131166530e-10
		,1.5233537020e-10
		,1.5336469980e-10
		,1.5439965860e-10
		,1.5544039340e-10
		,1.5648685490e-10
		,1.5753915650e-10
		,1.5859728580e-10
		,1.5966128810e-10
		,1.6073118020e-10
		,1.6180699010e-10
		,1.6288876900e-10
		,1.6397648110e-10
		,1.6507017820e-10
		,1.6616984410e-10
		,1.6727555850e-10
		,1.6838730290e-10
		,1.6950503460e-10
		,1.7062886360e-10
		,1.7175877100e-10
		,1.7289480880e-10
		,1.7403694670e-10
		,1.7518520790e-10
		,1.7633967870e-10
		,1.7750039730e-10
		,1.7866742380e-10
		,1.7984090570e-10
		,1.8102100190e-10
		,1.8220777560e-10
		,1.8340149230e-10
		,1.8460257830e-10
		,1.8581129540e-10
		,1.8702823450e-10
		,1.8825416060e-10
		,1.8949010070e-10
		,1.9073727950e-10
		,1.9199742880e-10
		,1.9327297050e-10
		,1.9456702280e-10
		,1.9588364260e-10
		,1.9722866710e-10
		,1.9860969000e-10
		,2.0003714790e-10
		,2.0152477660e-10
		,2.0309165100e-10
		,2.0472385310e-10
		,2.0647206330e-10
		,2.0837405470e-10
		,2.1047873640e-10
		,2.1285309890e-10
		,2.1558719200e-10
		,2.1880231160e-10
		,2.2266227620e-10
		,2.2738840810e-10
		,2.3328040390e-10
		,2.4056885060e-10
		,2.4944955580e-10
		,2.6071895300e-10
		,2.7513913150e-10
		,2.9371260860e-10
		,3.1777519680e-10
		,3.4909111550e-10
		,3.8999549460e-10
		,4.4358135280e-10
		,5.1394594230e-10
		,6.0651766550e-10
		,7.2849225920e-10
		,8.8941111670e-10
		,1.1019254690e-09
		,1.3828039510e-09
		,1.7542786640e-09
		,2.2458844470e-09
		,2.8967808790e-09
		,3.7589208350e-09
		,4.9012296490e-09
		,6.4151442400e-09
		,8.4219539030e-09
		,1.1082521210e-08
		,1.4610144730e-08
		,1.9287631520e-08
		,2.5411906360e-08
		,3.3513857400e-08
		,4.4234741830e-08
		,5.8412852710e-08
		,7.7149036860e-08
		,1.0188502920e-07
		,1.3450280110e-07
		////////////////////////////////
		,-1.5666608390e-18
		,3.8757224290e-11
		,6.6005599090e-11
		,8.5310121900e-11
		,9.9130599200e-11
		,1.0916391790e-10
		,1.1657986620e-10
		,1.2218433530e-10
		,1.2653217100e-10
		,1.3000485730e-10
		,1.3286442010e-10
		,1.3529044210e-10
		,1.3740595140e-10
		,1.3929505520e-10
		,1.4101541320e-10
		,1.4260672740e-10
		,1.4409667670e-10
		,1.4550532200e-10
		,1.4684761470e-10
		,1.4813548920e-10
		,1.4937897760e-10
		,1.5058665600e-10
		,1.5176606680e-10
		,1.5292383200e-10
		,1.5406548590e-10
		,1.5519584070e-10
		,1.5631859080e-10
		,1.5743695010e-10
		,1.5855334800e-10
		,1.5966969010e-10
		,1.6078741030e-10
		,1.6190776010e-10
		,1.6303158750e-10
		,1.6415952660e-10
		,1.6529218820e-10
		,1.6643001500e-10
		,1.6757327970e-10
		,1.6872220180e-10
		,1.6987708600e-10
		,1.7103809520e-10
		,1.7220527410e-10
		,1.7337880250e-10
		,1.7455874850e-10
		,1.7574525100e-10
		,1.7693830750e-10
		,1.7813798910e-10
		,1.7934436290e-10
		,1.8055743730e-10
		,1.8177729770e-10
		,1.8300387060e-10
		,1.8423731250e-10
		,1.8547760050e-10
		,1.8672478220e-10
		,1.8797881470e-10
		,1.8923972700e-10
		,1.9050761150e-10
		,1.9178234040e-10
		,1.9306403340e-10
		,1.9435263610e-10
		,1.9564825970e-10
		,1.9695082520e-10
		,1.9826045070e-10
		,1.9957700620e-10
		,2.0090058730e-10
		,2.0223128200e-10
		,2.0356903390e-10
		,2.0491397010e-10
		,2.0626607800e-10
		,2.0762556360e-10
		,2.0899238460e-10
		,2.1036677000e-10
		,2.1174889950e-10
		,2.1313911490e-10
		,2.1453760310e-10
		,2.1594486060e-10
		,2.1736156680e-10
		,2.1878840580e-10
		,2.2022639600e-10
		,2.2167708400e-10
		,2.2314216920e-10
		,2.2462426720e-10
		,2.2612671930e-10
		,2.2765401950e-10
		,2.2921230320e-10
		,2.3080979490e-10
		,2.3244276540e-10
		,2.3412588860e-10
		,2.3587889570e-10
		,2.3772218410e-10
		,2.3968293760e-10
		,2.4179882920e-10
		,2.4411981210e-10
		,2.4671310150e-10
		,2.4966970460e-10
		,2.5311206940e-10
		,2.5720577350e-10
		,2.6190295510e-10
		,2.6758706870e-10
		,2.7456615250e-10
		,2.8324469680e-10
		,2.9416316930e-10
		,3.0803074760e-10
		,3.2578658020e-10
		,3.4867056820e-10
		,3.7832172880e-10
		,4.1690780610e-10
		,4.6729660120e-10
		,5.3328325040e-10
		,6.1989147600e-10
		,7.3377466370e-10
		,8.8374489060e-10
		,1.0814769990e-09
		,1.3424098430e-09
		,1.6870540850e-09
		,2.1425894720e-09
		,2.7450431810e-09
		,3.5421857100e-09
		,4.5973653280e-09
		,5.9945945990e-09
		,7.8452894450e-09
		,1.0297267490e-08
		////////////////////////////////
		,1.3574558480e-18
		,1.8616075440e-14
		,3.1803371770e-14
		,4.1221220610e-14
		,4.8022402730e-14
		,5.3014183220e-14
		,5.6757418100e-14
		,5.9612609180e-14
		,6.1886370990e-14
		,6.3728877800e-14
		,6.5303827940e-14
		,6.6674037690e-14
		,6.7881906750e-14
		,6.8979494840e-14
		,7.0025545370e-14
		,7.1028778470e-14
		,7.1955201300e-14
		,7.2888203390e-14
		,7.3768101430e-14
		,7.4617505120e-14
		,7.5435109030e-14
		,7.6264983790e-14
		,7.7062954350e-14
		,7.7852570290e-14
		,7.8555715920e-14
		,7.9326272880e-14
		,8.0018818590e-14
		,8.0712251980e-14
		,8.1447928410e-14
		,8.2136557890e-14
		,8.2797669340e-14
		,8.3462227080e-14
		,8.4120309980e-14
		,8.4821784690e-14
		,8.5473706060e-14
		,8.6150639070e-14
		,8.6794571340e-14
		,8.7488213600e-14
		,8.8142171410e-14
		,8.8826675790e-14
		,8.9514991980e-14
		,9.0204300270e-14
		,9.0850164540e-14
		,9.1596754200e-14
		,9.2276298030e-14
		,9.2999703610e-14
		,9.3710577260e-14
		,9.4411790890e-14
		,9.5141932380e-14
		,9.5861265090e-14
		,9.6590832210e-14
		,9.7312775730e-14
		,9.8076492350e-14
		,9.8801464420e-14
		,9.9569306140e-14
		,1.0030252840e-13
		,1.0108410300e-13
		,1.0185032600e-13
		,1.0262182290e-13
		,1.0340731370e-13
		,1.0423181020e-13
		,1.0505876080e-13
		,1.0590022760e-13
		,1.0676910800e-13
		,1.0761323790e-13
		,1.0851480570e-13
		,1.0942253510e-13
		,1.1043709910e-13
		,1.1146456060e-13
		,1.1255087000e-13
		,1.1377894680e-13
		,1.1503563810e-13
		,1.1652025390e-13
		,1.1812042460e-13
		,1.2008981720e-13
		,1.2236149030e-13
		,1.2512545940e-13
		,1.2847754150e-13
		,1.3260498440e-13
		,1.3785011870e-13
		,1.4453595490e-13
		,1.5309834290e-13
		,1.6431494130e-13
		,1.7897275500e-13
		,1.9784500410e-13
		,2.1960586280e-13
		,2.4703021330e-13
		,2.8244868120e-13
		,3.2845688990e-13
		,3.8834457500e-13
		,4.6667403760e-13
		,5.6945861910e-13
		,7.0503685590e-13
		,8.8453798850e-13
		,1.1229645110e-12
		,1.4376992000e-12
		,1.8233486270e-12
		,2.3251389570e-12
		,2.9786418070e-12
		,3.8304998680e-12
		,4.9417659800e-12
		,6.3897192220e-12
		,8.2752888230e-12
		,1.0738402800e-11
		,1.3959660240e-11
		,1.8175455510e-11
		,2.3696500960e-11
		,3.0931685450e-11
		,4.0419352580e-11
		,5.2868294870e-11
		,6.9212476610e-11
		,9.0682937670e-11
		,1.1890324890e-10
		,1.5601522150e-10
		,2.0484584970e-10
		,2.6909792920e-10
		,3.5369405650e-10
		,4.6515438610e-10
		,6.1208026130e-10
		,8.0584632010e-10
		,1.0615014110e-09
		////////////////////////////////
		,-3.6553156190e-18
		,4.0575225120e-11
		,6.9245146310e-11
		,8.9694880360e-11
		,1.0447134680e-10
		,1.1533411550e-10
		,1.2349869600e-10
		,1.2980433610e-10
		,1.3483033240e-10
		,1.3897621160e-10
		,1.4251753900e-10
		,1.4564393550e-10
		,1.4848571480e-10
		,1.5113223880e-10
		,1.5364453650e-10
		,1.5606393340e-10
		,1.5841823720e-10
		,1.6072577500e-10
		,1.6299833150e-10
		,1.6524323820e-10
		,1.6746462530e-10
		,1.6966423910e-10
		,1.7184243160e-10
		,1.7399844170e-10
		,1.7613048570e-10
		,1.7823641740e-10
		,1.8031369610e-10
		,1.8235937040e-10
		,1.8437050020e-10
		,1.8634418240e-10
		,1.8827776810e-10
		,1.9016884610e-10
		,1.9201574400e-10
		,1.9381750720e-10
		,1.9557422910e-10
		,1.9728710500e-10
		,1.9895864200e-10
		,2.0059245160e-10
		,2.0219320440e-10
		,2.0376602730e-10
		,2.0531638990e-10
		,2.0684955870e-10
		,2.0837037320e-10
		,2.0988305420e-10
		,2.1139123900e-10
		,2.1289778350e-10
		,2.1440513300e-10
		,2.1591503080e-10
		,2.1742906000e-10
		,2.1894824850e-10
		,2.2047356980e-10
		,2.2200561760e-10
		,2.2354496640e-10
		,2.2509199700e-10
		,2.2664699180e-10
		,2.2821025640e-10
		,2.2978197130e-10
		,2.3136227380e-10
		,2.3295126700e-10
		,2.3454916390e-10
		,2.3615588000e-10
		,2.3777152920e-10
		,2.3939627660e-10
		,2.4103004740e-10
		,2.4267289560e-10
		,2.4432492540e-10
		,2.4598622830e-10
		,2.4765667330e-10
		,2.4933634150e-10
		,2.5102521370e-10
		,2.5272338440e-10
		,2.5443086530e-10
		,2.5614767470e-10
		,2.5787372620e-10
		,2.5960912890e-10
		,2.6135382110e-10
		,2.6310792310e-10
		,2.6487125900e-10
		,2.6664404310e-10
		,2.6842620590e-10
		,2.7021775810e-10
		,2.7201877180e-10
		,2.7382932460e-10
		,2.7564940360e-10
		,2.7747908720e-10
		,2.7931854720e-10
		,2.8116778480e-10
		,2.8302705620e-10
		,2.8489649960e-10
		,2.8677642370e-10
		,2.8866704940e-10
		,2.9056895700e-10
		,2.9248261660e-10
		,2.9440882990e-10
		,2.9634836820e-10
		,2.9830263020e-10
		,3.0027338040e-10
		,3.0226157870e-10
		,3.0426581750e-10
		,3.0629203970e-10
		,3.0834410840e-10
		,3.1042706540e-10
		,3.1254773960e-10
		,3.1471508520e-10
		,3.1694140590e-10
		,3.1924306870e-10
		,3.2164236640e-10
		,3.2416947960e-10
		,3.2685023240e-10
		,3.2968124890e-10
		,3.3274936740e-10
		,3.3612534170e-10
		,3.3990102790e-10
		,3.4419669440e-10
		,3.4917070680e-10
		,3.5503089700e-10
		,3.6205094800e-10
		,3.7059051400e-10
		,3.8112372630e-10
		,3.9427478680e-10
		,4.1086658290e-10
		////////////////////////////////
		,-2.0312337480e-17
		,4.1224228070e-11
		,7.0393435390e-11
		,9.1237301790e-11
		,1.0633438860e-10
		,1.1746747710e-10
		,1.2586844780e-10
		,1.3238866950e-10
		,1.3761623970e-10
		,1.4195728370e-10
		,1.4569235910e-10
		,1.4901483220e-10
		,1.5205820310e-10
		,1.5491425640e-10
		,1.5764615100e-10
		,1.6029702820e-10
		,1.6289632570e-10
		,1.6546386110e-10
		,1.6801276150e-10
		,1.7055162140e-10
		,1.7308565750e-10
		,1.7561777990e-10
		,1.7814938080e-10
		,1.8068051900e-10
		,1.8321057570e-10
		,1.8573818320e-10
		,1.8826169450e-10
		,1.9077895850e-10
		,1.9328769230e-10
		,1.9578521130e-10
		,1.9826884560e-10
		,2.0073550440e-10
		,2.0318207480e-10
		,2.0560518490e-10
		,2.0800130960e-10
		,2.1036698570e-10
		,2.1269868470e-10
		,2.1499289410e-10
		,2.1724639630e-10
		,2.1945617990e-10
		,2.2161986280e-10
		,2.2373560860e-10
		,2.2580256790e-10
		,2.2782094140e-10
		,2.2979215620e-10
		,2.3171911500e-10
		,2.3360577410e-10
		,2.3545727270e-10
		,2.3727941300e-10
		,2.3907810790e-10
		,2.4085905400e-10
		,2.4262757430e-10
		,2.4438823910e-10
		,2.4614502040e-10
		,2.4790103070e-10
		,2.4965886680e-10
		,2.5142042870e-10
		,2.5318741320e-10
		,2.5496093110e-10
		,2.5674200410e-10
		,2.5853127430e-10
		,2.6032931130e-10
		,2.6213654090e-10
		,2.6395330960e-10
		,2.6577986440e-10
		,2.6761646420e-10
		,2.6946313140e-10
		,2.7132013200e-10
		,2.7318744620e-10
		,2.7506526450e-10
		,2.7695356670e-10
		,2.7885246590e-10
		,2.8076196700e-10
		,2.8268216270e-10
		,2.8461292170e-10
		,2.8655449520e-10
		,2.8850676470e-10
		,2.9046974700e-10
		,2.9244349170e-10
		,2.9442805280e-10
		,2.9642334390e-10
		,2.9842941510e-10
		,3.0044635110e-10
		,3.0247408360e-10
		,3.0451262170e-10
		,3.0656201270e-10
		,3.0862233900e-10
		,3.1069350960e-10
		,3.1277560580e-10
		,3.1486870000e-10
		,3.1697277000e-10
		,3.1908793220e-10
		,3.2121426530e-10
		,3.2335179360e-10
		,3.2550070050e-10
		,3.2766111430e-10
		,3.2983320850e-10
		,3.3201723730e-10
		,3.3421352600e-10
		,3.3642242180e-10
		,3.3864443110e-10
		,3.4088026960e-10
		,3.4313074390e-10
		,3.4539701030e-10
		,3.4767734810e-10
		,3.4997498310e-10
		,3.5229182440e-10
		,3.5462976170e-10
		,3.5699159780e-10
		,3.5938163840e-10
		,3.6180508600e-10
		,3.6426897300e-10
		,3.6678276840e-10
		,3.6935918900e-10
		,3.7201540510e-10
		,3.7474637270e-10
		,3.7758623160e-10
		,3.8056732960e-10
		,3.8372886020e-10
		,3.8712198320e-10
		,3.9081356580e-10
		////////////////////////////////
		,-5.7454982050e-19
		,4.1774308570e-11
		,7.1365343740e-11
		,9.2540467180e-11
		,1.0790558450e-10
		,1.1926268220e-10
		,1.2785768970e-10
		,1.3455200080e-10
		,1.3994106700e-10
		,1.4443639380e-10
		,1.4832231860e-10
		,1.5179538850e-10
		,1.5499131130e-10
		,1.5800371010e-10
		,1.6089727630e-10
		,1.6371653390e-10
		,1.6649211150e-10
		,1.6924485860e-10
		,1.7198920600e-10
		,1.7473470080e-10
		,1.7748763060e-10
		,1.8025205460e-10
		,1.8303034580e-10
		,1.8582379770e-10
		,1.8863269960e-10
		,1.9145669890e-10
		,1.9429511020e-10
		,1.9714664610e-10
		,2.0000992410e-10
		,2.0288304710e-10
		,2.0576408820e-10
		,2.0865094800e-10
		,2.1154140050e-10
		,2.1443293490e-10
		,2.1732314950e-10
		,2.2020948040e-10
		,2.2308913960e-10
		,2.2595928520e-10
		,2.2881690270e-10
		,2.3165876010e-10
		,2.3448154610e-10
		,2.3728176960e-10
		,2.4005570210e-10
		,2.4279961540e-10
		,2.4550967910e-10
		,2.4818199730e-10
		,2.5081305120e-10
		,2.5339931680e-10
		,2.5593764870e-10
		,2.5842563360e-10
		,2.6086130900e-10
		,2.6324392540e-10
		,2.6557380700e-10
		,2.6785261270e-10
		,2.7008360750e-10
		,2.7227122760e-10
		,2.7442107310e-10
		,2.7653948310e-10
		,2.7863294930e-10
		,2.8070788390e-10
		,2.8276991660e-10
		,2.8482426800e-10
		,2.8687509230e-10
		,2.8892606890e-10
		,2.9097985220e-10
		,2.9303872010e-10
		,2.9510432120e-10
		,2.9717801750e-10
		,2.9926079930e-10
		,3.0135349640e-10
		,3.0345657290e-10
		,3.0557070970e-10
		,3.0769600700e-10
		,3.0983297480e-10
		,3.1198158100e-10
		,3.1414217140e-10
		,3.1631482580e-10
		,3.1849956700e-10
		,3.2069659930e-10
		,3.2290593530e-10
		,3.2512754350e-10
		,3.2736161480e-10
		,3.2960798830e-10
		,3.3186685300e-10
		,3.3413817100e-10
		,3.3642191790e-10
		,3.3871822130e-10
		,3.4102702830e-10
		,3.4334838710e-10
		,3.4568218560e-10
		,3.4802861960e-10
		,3.5038762660e-10
		,3.5275913860e-10
		,3.5514328230e-10
		,3.5753992280e-10
		,3.5994926960e-10
		,3.6237124950e-10
		,3.6480589720e-10
		,3.6725326320e-10
		,3.6971355800e-10
		,3.7218680220e-10
		,3.7467312060e-10
		,3.7717271300e-10
		,3.7968561000e-10
		,3.8221213710e-10
		,3.8475249430e-10
		,3.8730689750e-10
		,3.8987579900e-10
		,3.9245968460e-10
		,3.9505907920e-10
		,3.9767366710e-10
		,4.0030438780e-10
		,4.0295238420e-10
		,4.0561882770e-10
		,4.0830504460e-10
		,4.1101302680e-10
		,4.1374506240e-10
		,4.1650438460e-10
		,4.1929516960e-10
		,4.2212315180e-10
		,4.2499593020e-10
		////////////////////////////////
		,-7.8326251680e-18
		,2.7157083100e-11
		,4.8963770420e-11
		,6.6950569590e-11
		,8.2244278760e-11
		,9.5673692000e-11
		,1.0783545380e-10
		,1.1914217390e-10
		,1.2986477000e-10
		,1.4016719750e-10
		,1.5013867960e-10
		,1.5983537960e-10
		,1.6931994330e-10
		,1.7867908700e-10
		,1.8801583070e-10
		,1.9743850680e-10
		,2.0705727180e-10
		,2.1698912460e-10
		,2.2734038870e-10
		,2.3819997340e-10
		,2.4964506340e-10
		,2.6175318790e-10
		,2.7461252400e-10
		,2.8832873610e-10
		,3.0303217110e-10
		,3.1888781740e-10
		,3.3610971280e-10
		,3.5498242820e-10
		,3.7587734120e-10
		,3.9931632670e-10
		,4.2601136650e-10
		,4.5692875580e-10
		,4.9339049850e-10
		,5.3721941720e-10
		,5.9055224190e-10
		,6.5700886460e-10
		,7.4132207340e-10
		,8.4898217010e-10
		,9.8774733990e-10
		,1.1700825640e-09
		,1.4116997760e-09
		,1.7347285940e-09
		,2.1693179610e-09
		,2.7568573450e-09
		,3.5542787240e-09
		,4.6397422100e-09
		,6.1203744180e-09
		,8.0785693260e-09
		,1.0707262510e-08
		,1.4260123000e-08
		,1.9062987230e-08
		,2.5555240640e-08
		,3.4328403680e-08
		,4.6177141610e-08
		,6.2166251100e-08
		,8.3714668980e-08
		,1.1261266960e-07
		,1.5133524270e-07
		,2.0315453070e-07
		,2.7223202100e-07
		,3.6407707590e-07
		,4.8566614660e-07
		,6.4579962640e-07
		,8.5540671820e-07
		,1.1278139410e-06
		,1.4789298120e-06
		,1.9272913880e-06
		,2.4939222510e-06
		,3.2008297320e-06
		,4.0691983570e-06
		,5.1249954960e-06
		,6.3803188390e-06
		,7.8527394260e-06
		,9.5689884090e-06
		,1.1546418070e-05
		,1.3799144710e-05
		,1.6338815350e-05
		,1.9174781860e-05
		,2.2314597480e-05
		,2.5764288430e-05
		,2.9528559270e-05
		,3.3611463870e-05
		,3.8016961320e-05
		,4.2746978940e-05
		,4.7802190430e-05
		,5.3183872490e-05
		,5.8898760810e-05
		,6.4948937350e-05
		,7.1334496820e-05
		,7.8065957800e-05
		,8.5124168430e-05
		,9.2507534970e-05
		,1.0011394320e-04
		,1.0804904310e-04
		,1.1629585830e-04
		,1.2470829280e-04
		,1.3331636500e-04
		,1.4222807800e-04
		,1.5144824670e-04
		,1.6098347270e-04
		,1.7084248130e-04
		,1.8103649920e-04
		,1.9120573820e-04
		,2.0151652410e-04
		,2.1192320270e-04
		,2.2273767410e-04
		,2.3399078560e-04
		,2.4530933540e-04
		,2.5609958420e-04
		,2.6675379490e-04
		,2.7769537260e-04
		,2.8889464980e-04
		,3.0033398700e-04
		,3.1200179960e-04
		,3.2389017670e-04
		,3.3599361090e-04
		,3.4830818640e-04
		,3.6080346220e-04
		,3.7348718900e-04
		,3.8635913180e-04
		,3.9930557720e-04
		////////////////////////////////
		,2.0520863460e-17
		,9.7361622800e-11
		,1.7185369890e-10
		,2.3005572140e-10
		,2.7670842400e-10
		,3.1522376980e-10
		,3.4806357200e-10
		,3.7701287620e-10
		,4.0336840270e-10
		,4.2806768150e-10
		,4.5177489100e-10
		,4.7493718240e-10
		,4.9782717160e-10
		,5.2059272620e-10
		,5.4331117840e-10
		,5.6601835610e-10
		,5.8870155590e-10
		,6.1129303880e-10
		,6.3369177550e-10
		,6.5580491930e-10
		,6.7756340050e-10
		,6.9891598930e-10
		,7.1983347820e-10
		,7.4032711760e-10
		,7.6043167650e-10
		,7.8019090360e-10
		,7.9965294880e-10
		,8.1886287050e-10
		,8.3786006330e-10
		,8.5669198140e-10
		,8.7543390010e-10
		,8.9421659070e-10
		,9.1323459510e-10
		,9.3275742000e-10
		,9.5314088080e-10
		,9.7482463580e-10
		,9.9835251610e-10
		,1.0244145610e-09
		,1.0539127960e-09
		,1.0880529720e-09
		,1.1284670610e-09
		,1.1773791540e-09
		,1.2378118570e-09
		,1.3133995990e-09
		,1.4078759560e-09
		,1.5298450640e-09
		,1.6892623050e-09
		,1.8994461290e-09
		,2.1787839320e-09
		,2.5527521160e-09
		,3.0552265160e-09
		,3.7333150520e-09
		,4.6504918440e-09
		,5.8596175810e-09
		,7.4228853920e-09
		,9.5073225900e-09
		,1.2288382830e-08
		,1.6000073650e-08
		,2.0954141850e-08
		,2.7565691780e-08
		,3.6386497000e-08
		,4.8148768430e-08
		,6.3822072250e-08
		,8.4686802030e-08
		,1.1242828440e-07
		,1.4925596520e-07
		,1.9804053670e-07
		,2.6238349480e-07
		,3.4716807320e-07
		,4.5849954080e-07
		,6.0408406820e-07
		,7.9352937600e-07
		,1.0386422320e-06
		,1.3536903690e-06
		,1.7555856090e-06
		,2.2639375910e-06
		,2.9009278550e-06
		,3.6909663860e-06
		,4.6601194570e-06
		,5.8353358540e-06
		,7.2435403380e-06
		,8.9106964460e-06
		,1.0860952010e-05
		,1.3115967630e-05
		,1.5694492420e-05
		,1.8612034270e-05
		,2.1875519020e-05
		,2.5497624120e-05
		,2.9475115890e-05
		,3.3814089160e-05
		,3.8509609400e-05
		,4.3543183430e-05
		,4.8930694170e-05
		,5.4668459170e-05
		,6.0753482070e-05
		,6.7178258440e-05
		,7.3942206880e-05
		,8.1035120490e-05
		,8.8457188120e-05
		,9.6203357990e-05
		,1.0427056330e-04
		,1.1267127870e-04
		,1.2141152820e-04
		,1.3049952160e-04
		,1.3994634930e-04
		,1.4976615120e-04
		,1.5982933910e-04
		,1.7009529040e-04
		,1.8040369020e-04
		,1.9058102960e-04
		,2.0101992580e-04
		,2.1171284950e-04
		,2.2265332630e-04
		,2.3383561250e-04
		,2.4525451110e-04
		,2.5690526700e-04
		,2.6845132270e-04
		,2.8008440200e-04
		,2.9188957940e-04
		,3.0386086000e-04
		,3.1599244600e-04
		////////////////////////////////
		,2.1929177690e-18
		,2.4573998210e-10
		,4.2272985360e-10
		,5.5134668120e-10
		,6.4622192490e-10
		,7.1767286470e-10
		,7.7291303910e-10
		,8.1690806890e-10
		,8.5303920770e-10
		,8.8359933000e-10
		,9.1016036450e-10
		,9.3383988360e-10
		,9.5541666260e-10
		,9.7542795380e-10
		,9.9426935730e-10
		,1.0122445380e-09
		,1.0295953880e-09
		,1.0465116730e-09
		,1.0631333890e-09
		,1.0795557800e-09
		,1.0958370830e-09
		,1.1120070580e-09
		,1.1280716750e-09
		,1.1440153450e-09
		,1.1598068850e-09
		,1.1754138480e-09
		,1.1908172280e-09
		,1.2060065320e-09
		,1.2209652560e-09
		,1.2356717530e-09
		,1.2501077750e-09
		,1.2642721550e-09
		,1.2781837910e-09
		,1.2918753160e-09
		,1.3053928640e-09
		,1.3187968240e-09
		,1.3321581550e-09
		,1.3455571620e-09
		,1.3590853090e-09
		,1.3728501050e-09
		,1.3869828630e-09
		,1.4016501840e-09
		,1.4170699850e-09
		,1.4335322580e-09
		,1.4514269700e-09
		,1.4712824620e-09
		,1.4938167900e-09
		,1.5200092780e-09
		,1.5512000940e-09
		,1.5892289130e-09
		,1.6350233030e-09
		,1.6926331930e-09
		,1.7664312290e-09
		,1.8622693550e-09
		,1.9881040800e-09
		,2.1547538590e-09
		,2.3769674340e-09
		,2.6748150200e-09
		,3.0756293440e-09
		,3.6149537150e-09
		,4.2915629170e-09
		,5.1886329730e-09
		,6.3796415700e-09
		,7.9617218980e-09
		,1.0064641170e-08
		,1.2860769550e-08
		,1.6579360670e-08
		,2.1524887810e-08
		,2.8101316210e-08
		,3.6843875840e-08
		,4.8460604460e-08
		,6.3886331120e-08
		,8.4352302230e-08
		,1.1147534660e-07
		,1.4736489320e-07
		,1.9462597530e-07
		,2.5690739640e-07
		,3.3876487000e-07
		,4.4600785600e-07
		,5.8597338030e-07
		,7.6782261770e-07
		,1.0028425500e-06
		,1.3047249030e-06
		,1.6897839030e-06
		,2.1770656920e-06
		,2.7882990960e-06
		,3.5476440500e-06
		,4.4812134950e-06
		,5.6163766990e-06
		,6.9804728070e-06
		,8.6007940200e-06
		,1.0502941460e-05
		,1.2710131730e-05
		,1.5242633930e-05
		,1.8117430880e-05
		,2.1348141970e-05
		,2.4943797950e-05
		,2.8910871990e-05
		,3.3254708040e-05
		,3.7977534370e-05
		,4.3079774000e-05
		,4.8560408460e-05
		,5.4417418070e-05
		,6.0647977910e-05
		,6.7247888440e-05
		,7.4201239030e-05
		,8.1511172790e-05
		,8.9174878150e-05
		,9.7187141850e-05
		,1.0554411320e-04
		,1.1424111210e-04
		,1.2327338290e-04
		,1.3263597580e-04
		,1.4232400140e-04
		,1.5233235520e-04
		,1.6259004650e-04
		,1.7277037080e-04
		,1.8323541780e-04
		,1.9397660530e-04
		,2.0498572610e-04
		,2.1625488960e-04
		////////////////////////////////
		,-6.2676618410e-19
		,3.4897018330e-10
		,5.9417218730e-10
		,7.6764179650e-10
		,8.9149706890e-10
		,9.8098974310e-10
		,1.0466426850e-09
		,1.0957705730e-09
		,1.1334705300e-09
		,1.1632682770e-09
		,1.1876009270e-09
		,1.2081579470e-09
		,1.2261007740e-09
		,1.2422241490e-09
		,1.2570815860e-09
		,1.2710486880e-09
		,1.2843747350e-09
		,1.2972187570e-09
		,1.3096796250e-09
		,1.3218200840e-09
		,1.3336838860e-09
		,1.3453101360e-09
		,1.3567432400e-09
		,1.3680327500e-09
		,1.3792229300e-09
		,1.3903434900e-09
		,1.4014123920e-09
		,1.4124403270e-09
		,1.4234338270e-09
		,1.4343948560e-09
		,1.4453193420e-09
		,1.4562035300e-09
		,1.4670561050e-09
		,1.4778965590e-09
		,1.4887426860e-09
		,1.4996073340e-09
		,1.5104988940e-09
		,1.5214233050e-09
		,1.5323856000e-09
		,1.5433912380e-09
		,1.5544469140e-09
		,1.5655614250e-09
		,1.5767465630e-09
		,1.5880182110e-09
		,1.5993982400e-09
		,1.6109174620e-09
		,1.6226195440e-09
		,1.6345647810e-09
		,1.6468369200e-09
		,1.6595508690e-09
		,1.6728629800e-09
		,1.6869844380e-09
		,1.7022010080e-09
		,1.7189014250e-09
		,1.7376202660e-09
		,1.7590961090e-09
		,1.7837767110e-09
		,1.8129975170e-09
		,1.8486223850e-09
		,1.8929301170e-09
		,1.9490112160e-09
		,2.0210639500e-09
		,2.1147974670e-09
		,2.2379812030e-09
		,2.4011927260e-09
		,2.6188369570e-09
		,2.8960894520e-09
		,3.2543340350e-09
		,3.7271497100e-09
		,4.3524428720e-09
		,5.1806633710e-09
		,6.2789496300e-09
		,7.7365619390e-09
		,9.6722903890e-09
		,1.2243985110e-08
		,1.5661339070e-08
		,2.0202701230e-08
		,2.6237362960e-08
		,3.4254599230e-08
		,4.4901640000e-08
		,5.9033167520e-08
		,7.7775320570e-08
		,1.0260756590e-07
		,1.3532430210e-07
		,1.7852934760e-07
		,2.3547000890e-07
		,3.1032924230e-07
		,4.0845427300e-07
		,5.3661970450e-07
		,7.0331859400e-07
		,9.1906363580e-07
		,1.1966791350e-06
		,1.5515471110e-06
		,2.0017640820e-06
		,2.5681591250e-06
		,3.2741263900e-06
		,4.1452394760e-06
		,5.2086422930e-06
		,6.4922477160e-06
		,8.0238137520e-06
		,9.8297257890e-06
		,1.1933847980e-05
		,1.4358580750e-05
		,1.7122583290e-05
		,2.0241150460e-05
		,2.3726247790e-05
		,2.7586733070e-05
		,3.1828706770e-05
		,3.6455934250e-05
		,4.1470270870e-05
		,4.6872047940e-05
		,5.2660419070e-05
		,5.8833676060e-05
		,6.5389552580e-05
		,7.2325544860e-05
		,7.9638928030e-05
		,8.7326811300e-05
		,9.5386239280e-05
		,1.0381425060e-04
		,1.1260790590e-04
		,1.2176423390e-04
		////////////////////////////////
		,1.2270677080e-17
		,4.1271095430e-10
		,6.9921759050e-10
		,8.9912933630e-10
		,1.0396376770e-09
		,1.1394002420e-09
		,1.2112122320e-09
		,1.2638436850e-09
		,1.3033032150e-09
		,1.3337019420e-09
		,1.3578509400e-09
		,1.3776846670e-09
		,1.3945456130e-09
		,1.4093680000e-09
		,1.4228020000e-09
		,1.4352950140e-09
		,1.4471526840e-09
		,1.4585833490e-09
		,1.4697293310e-09
		,1.4806882930e-09
		,1.4915271390e-09
		,1.5022923340e-09
		,1.5130167700e-09
		,1.5237232170e-09
		,1.5344273710e-09
		,1.5451401860e-09
		,1.5558694140e-09
		,1.5666206250e-09
		,1.5773979010e-09
		,1.5882044130e-09
		,1.5990423220e-09
		,1.6099131690e-09
		,1.6208180980e-09
		,1.6317580400e-09
		,1.6427338870e-09
		,1.6537464560e-09
		,1.6647968060e-09
		,1.6758860310e-09
		,1.6870150590e-09
		,1.6981850810e-09
		,1.7093968720e-09
		,1.7206517390e-09
		,1.7319509780e-09
		,1.7432962080e-09
		,1.7546890820e-09
		,1.7661318450e-09
		,1.7776269680e-09
		,1.7891777020e-09
		,1.8007879890e-09
		,1.8124632050e-09
		,1.8242094530e-09
		,1.8360332570e-09
		,1.8479398390e-09
		,1.8599355990e-09
		,1.8720418190e-09
		,1.8843143190e-09
		,1.8968419100e-09
		,1.9097335460e-09
		,1.9231205650e-09
		,1.9371699320e-09
		,1.9521024150e-09
		,1.9682148840e-09
		,1.9857293260e-09
		,2.0050107780e-09
		,2.0268695480e-09
		,2.0521876830e-09
		,2.0821646720e-09
		,2.1184283310e-09
		,2.1631893520e-09
		,2.2194516310e-09
		,2.2912998950e-09
		,2.3842898900e-09
		,2.5034396020e-09
		,2.6519534900e-09
		,2.8450881990e-09
		,3.0975166870e-09
		,3.4287565400e-09
		,3.8647710870e-09
		,4.4400965510e-09
		,5.2006699800e-09
		,6.2075845800e-09
		,7.5420732320e-09
		,9.3121164720e-09
		,1.1661193720e-08
		,1.4779856220e-08
		,1.8921001940e-08
		,2.4420008820e-08
		,3.1721126640e-08
		,4.1412103640e-08
		,5.4269371680e-08
		,7.1316815330e-08
		,9.3777824740e-08
		,1.2347779040e-07
		,1.6269745500e-07
		,2.1439308850e-07
		,2.8238024470e-07
		,3.7154905760e-07
		,4.8811435490e-07
		,6.3989585720e-07
		,8.3661707130e-07
		,1.0902027530e-06
		,1.4150445800e-06
		,1.8281945350e-06
		,2.3494382250e-06
		,3.0011997060e-06
		,3.8082391200e-06
		,4.7971268860e-06
		,5.9955116880e-06
		,7.4312378350e-06
		,9.1314012470e-06
		,1.1121449160e-05
		,1.3424423570e-05
		,1.6060422120e-05
		,1.9046309730e-05
		,2.2395673120e-05
		,2.6118979480e-05
		,3.0223880440e-05
		,3.4715619180e-05
		,3.9597489710e-05
		,4.4871747020e-05
		,5.0538766880e-05
		////////////////////////////////
		,1.5873606570e-17
		,4.5899104930e-10
		,7.7678742870e-10
		,9.9781732440e-10
		,1.1525521480e-09
		,1.2618815500e-09
		,1.3401213420e-09
		,1.3970794540e-09
		,1.4394734780e-09
		,1.4719036390e-09
		,1.4975216250e-09
		,1.5184869990e-09
		,1.5362782370e-09
		,1.5519072380e-09
		,1.5660666330e-09
		,1.5792304430e-09
		,1.5917229500e-09
		,1.6037652150e-09
		,1.6155071150e-09
		,1.6270481590e-09
		,1.6384506780e-09
		,1.6497462700e-09
		,1.6609437940e-09
		,1.6720510290e-09
		,1.6830991660e-09
		,1.6941321660e-09
		,1.7051835390e-09
		,1.7162734080e-09
		,1.7274132050e-09
		,1.7386095450e-09
		,1.7498666200e-09
		,1.7611869400e-09
		,1.7725720910e-09
		,1.7840230070e-09
		,1.7955404210e-09
		,1.8071245760e-09
		,1.8187758610e-09
		,1.8304942970e-09
		,1.8422799600e-09
		,1.8541328800e-09
		,1.8660530160e-09
		,1.8780403270e-09
		,1.8900948790e-09
		,1.9022165560e-09
		,1.9144053630e-09
		,1.9266614670e-09
		,1.9389847080e-09
		,1.9513752480e-09
		,1.9638335190e-09
		,1.9763599190e-09
		,1.9889551170e-09
		,2.0016198950e-09
		,2.0143556510e-09
		,2.0271640850e-09
		,2.0400475440e-09
		,2.0530092300e-09
		,2.0660534990e-09
		,2.0791863420e-09
		,2.0924155200e-09
		,2.1057518620e-09
		,2.1192099240e-09
		,2.1328091530e-09
		,2.1465760220e-09
		,2.1605462630e-09
		,2.1747680630e-09
		,2.1893069000e-09
		,2.2042515150e-09
		,2.2197221290e-09
		,2.2358397610e-09
		,2.2526616490e-09
		,2.2705584100e-09
		,2.2898794490e-09
		,2.3110970210e-09
		,2.3348515870e-09
		,2.3620109480e-09
		,2.3937512910e-09
		,2.4316704240e-09
		,2.4779379270e-09
		,2.5355019860e-09
		,2.6042090140e-09
		,2.6903216050e-09
		,2.7997727560e-09
		,2.9401802290e-09
		,3.1216653190e-09
		,3.3576786390e-09
		,3.6660928060e-09
		,4.0706647180e-09
		,4.6029745670e-09
		,5.3049926490e-09
		,6.2324968320e-09
		,7.4596037360e-09
		,9.0847763380e-09
		,1.1238778490e-08
		,1.4095197940e-08
		,1.7884344960e-08
		,2.2911575650e-08
		,2.9581398020e-08
		,3.8429104600e-08
		,5.0162163760e-08
		,6.5608929600e-08
		,8.6043844000e-08
		,1.1306010730e-07
		,1.4872947660e-07
		,1.9574519560e-07
		,2.5758925050e-07
		,3.3873420660e-07
		,4.4488021990e-07
		,5.8322436520e-07
		,7.6275363130e-07
		,9.9454491460e-07
		,1.2920456220e-06
		,1.6712981390e-06
		,2.1510628450e-06
		,2.7527909970e-06
		,3.5004043610e-06
		,4.4198561740e-06
		,5.5384774990e-06
		,6.8841500450e-06
		,8.4843823050e-06
		,1.0365389610e-05
		,1.2551280030e-05
		////////////////////////////////
		,-4.4907775280e-18
		,4.9806069890e-10
		,8.4381872290e-10
		,1.0848488280e-09
		,1.2538958380e-09
		,1.3734879160e-09
		,1.4591190220e-09
		,1.5214416880e-09
		,1.5677769640e-09
		,1.6031543530e-09
		,1.6310279170e-09
		,1.6537689370e-09
		,1.6730051810e-09
		,1.6898542130e-09
		,1.7050830360e-09
		,1.7192182530e-09
		,1.7326215080e-09
		,1.7455411990e-09
		,1.7581481610e-09
		,1.7705599360e-09
		,1.7828575960e-09
		,1.7950969470e-09
		,1.8073166050e-09
		,1.8195434110e-09
		,1.8317960490e-09
		,1.8440876460e-09
		,1.8564273570e-09
		,1.8688216050e-09
		,1.8812751470e-09
		,1.8937911970e-09
		,1.9063722280e-09
		,1.9190199250e-09
		,1.9317356810e-09
		,1.9445204720e-09
		,1.9573751480e-09
		,1.9703002340e-09
		,1.9832961530e-09
		,1.9963633800e-09
		,2.0095022280e-09
		,2.0227129420e-09
		,2.0359956920e-09
		,2.0493506270e-09
		,2.0627779240e-09
		,2.0762777690e-09
		,2.0898500890e-09
		,2.1034951060e-09
		,2.1172127750e-09
		,2.1310032240e-09
		,2.1448665030e-09
		,2.1588026100e-09
		,2.1728117040e-09
		,2.1868938210e-09
		,2.2010489760e-09
		,2.2152772910e-09
		,2.2295789890e-09
		,2.2439543370e-09
		,2.2584037320e-09
		,2.2729275450e-09
		,2.2875264230e-09
		,2.3022012150e-09
		,2.3169529770e-09
		,2.3317833520e-09
		,2.3466940350e-09
		,2.3616879170e-09
		,2.3767685000e-09
		,2.3919403670e-09
		,2.4072100060e-09
		,2.4225858100e-09
		,2.4380791010e-09
		,2.4537049760e-09
		,2.4694839400e-09
		,2.4854436180e-09
		,2.5016210620e-09
		,2.5180666220e-09
		,2.5348480680e-09
		,2.5519434730e-09
		,2.5695251710e-09
		,2.5877344410e-09
		,2.6067606020e-09
		,2.6268592260e-09
		,2.6483755900e-09
		,2.6717767230e-09
		,2.6976953310e-09
		,2.7269883970e-09
		,2.7608186590e-09
		,2.7997521160e-09
		,2.8451860350e-09
		,2.8999432210e-09
		,2.9670230310e-09
		,3.0504043350e-09
		,3.1553672620e-09
		,3.2889190950e-09
		,3.4603618640e-09
		,3.6820456610e-09
		,3.9703698530e-09
		,4.3471124500e-09
		,4.8411805820e-09
		,5.4909898190e-09
		,6.3475482820e-09
		,7.4785964360e-09
		,8.9740670740e-09
		,1.0953339090e-08
		,1.3574821760e-08
		,1.7048627660e-08
		,2.1653299920e-08
		,2.7757856280e-08
		,3.5850807400e-08
		,4.6488640770e-08
		,6.0558832140e-08
		,7.9170216290e-08
		,1.0376561050e-07
		,1.3623028100e-07
		,1.7901753790e-07
		,2.3530385210e-07
		,3.0917777150e-07
		,4.0586322660e-07
		,5.3197701110e-07
		,6.9581376910e-07
		,9.0764505700e-07
		,1.1800100190e-06
		,1.5279647560e-06
		////////////////////////////////
		,1.2008067450e-18
		,5.2482796930e-10
		,8.9212629850e-10
		,1.1507457400e-09
		,1.3343494920e-09
		,1.4661278110e-09
		,1.5620522960e-09
		,1.6331232120e-09
		,1.6869199740e-09
		,1.7286715790e-09
		,1.7619937020e-09
		,1.7893960320e-09
		,1.8126288070e-09
		,1.8329198640e-09
		,1.8511354270e-09
		,1.8678894620e-09
		,1.8836188740e-09
		,1.8986349940e-09
		,1.9131602890e-09
		,1.9273534860e-09
		,1.9413281540e-09
		,1.9551655140e-09
		,1.9689238700e-09
		,1.9826450150e-09
		,1.9963590410e-09
		,2.0100879740e-09
		,2.0238476870e-09
		,2.0376498510e-09
		,2.0515032710e-09
		,2.0654143610e-09
		,2.0793879960e-09
		,2.0934279750e-09
		,2.1075372940e-09
		,2.1217181550e-09
		,2.1359724980e-09
		,2.1503017440e-09
		,2.1647071120e-09
		,2.1791896430e-09
		,2.1937502270e-09
		,2.2083895250e-09
		,2.2231082250e-09
		,2.2379068050e-09
		,2.2527857480e-09
		,2.2677454460e-09
		,2.2827861770e-09
		,2.2979083840e-09
		,2.3131121440e-09
		,2.3283978700e-09
		,2.3437656070e-09
		,2.3592155570e-09
		,2.3747478770e-09
		,2.3903626790e-09
		,2.4060600530e-09
		,2.4218401150e-09
		,2.4377029610e-09
		,2.4536486180e-09
		,2.4696771180e-09
		,2.4857886760e-09
		,2.5019831440e-09
		,2.5182607520e-09
		,2.5346215700e-09
		,2.5510657180e-09
		,2.5675934170e-09
		,2.5842049920e-09
		,2.6009007020e-09
		,2.6176809530e-09
		,2.6345464450e-09
		,2.6514978340e-09
		,2.6685360880e-09
		,2.6856625820e-09
		,2.7028789920e-09
		,2.7201874430e-09
		,2.7375910540e-09
		,2.7550936010e-09
		,2.7727001690e-09
		,2.7904176920e-09
		,2.8082551930e-09
		,2.8262247920e-09
		,2.8443423920e-09
		,2.8626296780e-09
		,2.8811156560e-09
		,2.8997973550e-09
		,2.9187274270e-09
		,2.9379751350e-09
		,2.9576178000e-09
		,2.9777593350e-09
		,2.9985396860e-09
		,3.0201473010e-09
		,3.0428350700e-09
		,3.0669471960e-09
		,3.0929488480e-09
		,3.1213246650e-09
		,3.1521880220e-09
		,3.1868662810e-09
		,3.2265542510e-09
		,3.2728326650e-09
		,3.3277950580e-09
		,3.3942126110e-09
		,3.4757561010e-09
		,3.5773001710e-09
		,3.7053023420e-09
		,3.8683265890e-09
		,4.0777332090e-09
		,4.3485934670e-09
		,4.7009053810e-09
		,5.1612067780e-09
		,5.7647053200e-09
		,6.5581313010e-09
		,7.6035134700e-09
		,8.9831576030e-09
		,1.0806263190e-08
		,1.3217687760e-08
		,1.6409539010e-08
		,2.0636504420e-08
		,2.6236123480e-08
		,3.3579303220e-08
		,4.3283336080e-08
		,5.6118930600e-08
		,7.3086780800e-08
		,9.5499288810e-08
		,1.2507201830e-07
		////////////////////////////////
		,-5.7439703960e-18
		,5.4260980120e-10
		,9.2438563710e-10
		,1.1951490440e-09
		,1.3892773190e-09
		,1.5304819390e-09
		,1.6351092380e-09
		,1.7144211710e-09
		,1.7761700590e-09
		,1.8256863830e-09
		,1.8666300210e-09
		,1.9015089970e-09
		,1.9320386930e-09
		,1.9593894380e-09
		,1.9843595380e-09
		,2.0074950540e-09
		,2.0291736390e-09
		,2.0496633940e-09
		,2.0691635100e-09
		,2.0878319340e-09
		,2.1058019600e-09
		,2.1231921890e-09
		,2.1401101230e-09
		,2.1566528080e-09
		,2.1729063780e-09
		,2.1889451770e-09
		,2.2048317540e-09
		,2.2206174630e-09
		,2.2363436610e-09
		,2.2520431590e-09
		,2.2677417510e-09
		,2.2834595630e-09
		,2.2992121400e-09
		,2.3150116630e-09
		,2.3308675080e-09
		,2.3467870640e-09
		,2.3627761190e-09
		,2.3788391940e-09
		,2.3949799260e-09
		,2.4112012320e-09
		,2.4275054740e-09
		,2.4438946100e-09
		,2.4603701970e-09
		,2.4769335490e-09
		,2.4935858430e-09
		,2.5103280380e-09
		,2.5271608120e-09
		,2.5440849790e-09
		,2.5611010910e-09
		,2.5782096150e-09
		,2.5954110270e-09
		,2.6127057690e-09
		,2.6300939720e-09
		,2.6475761720e-09
		,2.6651524570e-09
		,2.6828230780e-09
		,2.7005881900e-09
		,2.7184480450e-09
		,2.7364026450e-09
		,2.7544521470e-09
		,2.7725966910e-09
		,2.7908362760e-09
		,2.8091710110e-09
		,2.8276010120e-09
		,2.8461262060e-09
		,2.8647467300e-09
		,2.8834626640e-09
		,2.9022741780e-09
		,2.9211813250e-09
		,2.9401842800e-09
		,2.9592833560e-09
		,2.9784787270e-09
		,2.9977707760e-09
		,3.0171599370e-09
		,3.0366468000e-09
		,3.0562321450e-09
		,3.0759168410e-09
		,3.0957021000e-09
		,3.1155895440e-09
		,3.1355811160e-09
		,3.1556794270e-09
		,3.1758879380e-09
		,3.1962107420e-09
		,3.2166537330e-09
		,3.2372243070e-09
		,3.2579321290e-09
		,3.2787902650e-09
		,3.2998020790e-09
		,3.3209790250e-09
		,3.3423568100e-09
		,3.3639680460e-09
		,3.3858563460e-09
		,3.4080798030e-09
		,3.4307164050e-09
		,3.4538705350e-09
		,3.4776812420e-09
		,3.5023391760e-09
		,3.5280987330e-09
		,3.5549664580e-09
		,3.5834157420e-09
		,3.6139796170e-09
		,3.6472945990e-09
		,3.6842014940e-09
		,3.7258111950e-09
		,3.7735924230e-09
		,3.8294876480e-09
		,3.8960671910e-09
		,3.9767233010e-09
		,4.0759618390e-09
		,4.1997510330e-09
		,4.3559939720e-09
		,4.5551645190e-09
		,4.8111459830e-09
		,5.1423444360e-09
		,5.5731663830e-09
		,6.1359706400e-09
		,6.8736884310e-09
		,7.8432503630e-09
		,9.1200710410e-09
		,1.0804358980e-08
		,1.3028938930e-08
		////////////////////////////////
		,1.3574558480e-18
		,1.8616075440e-14
		,3.1803476210e-14
		,4.1225554560e-14
		,4.8031540590e-14
		,5.3019718150e-14
		,5.6757418100e-14
		,5.9613810160e-14
		,6.1880836060e-14
		,6.3733263980e-14
		,6.5301530420e-14
		,6.6661088030e-14
		,6.7883003290e-14
		,6.8980539160e-14
		,7.0037764000e-14
		,7.1028517390e-14
		,7.1962877110e-14
		,7.2892171830e-14
		,7.3766639370e-14
		,7.4614215480e-14
		,7.5434221350e-14
		,7.6242374100e-14
		,7.7065304080e-14
		,7.7847505300e-14
		,7.8554514940e-14
		,7.9326481750e-14
		,8.0018818590e-14
		,8.0712251980e-14
		,8.1448032840e-14
		,8.2135356910e-14
		,8.2795632900e-14
		,8.3463532490e-14
		,8.4126575940e-14
		,8.4815309860e-14
		,8.5473340550e-14
		,8.6151787840e-14
		,8.6795406810e-14
		,8.7474167390e-14
		,8.8142014760e-14
		,8.8826884660e-14
		,8.9514991980e-14
		,9.0208112070e-14
		,9.0854080770e-14
		,9.1596754200e-14
		,9.2275044830e-14
		,9.2997562740e-14
		,9.3710577260e-14
		,9.4399258960e-14
		,9.5128512780e-14
		,9.5857975460e-14
		,9.6581589910e-14
		,9.7310687070e-14
		,9.8053621580e-14
		,9.8795825060e-14
		,9.9550299380e-14
		,1.0030273730e-13
		,1.0106828150e-13
		,1.0184124040e-13
		,1.0263205730e-13
		,1.0338830700e-13
		,1.0423092250e-13
		,1.0505092840e-13
		,1.0590033210e-13
		,1.0677939470e-13
		,1.0759945270e-13
		,1.0850994960e-13
		,1.0942091630e-13
		,1.1043360060e-13
		,1.1146330740e-13
		,1.1255259310e-13
		,1.1374150760e-13
		,1.1503459380e-13
		,1.1652161160e-13
		,1.1811870140e-13
		,1.2008798960e-13
		,1.2236117700e-13
		,1.2512310970e-13
		,1.2849884580e-13
		,1.3260540210e-13
		,1.3784996210e-13
		,1.4453997550e-13
		,1.5312173590e-13
		,1.6431274820e-13
		,1.7897155400e-13
		,1.9784599620e-13
		,2.1960074560e-13
		,2.4702979560e-13
		,2.8244873340e-13
		,3.2846002280e-13
		,3.8833486280e-13
		,4.6666296770e-13
		,5.6946540720e-13
		,7.0502521170e-13
		,8.8453715310e-13
		,1.1229651370e-12
		,1.4376993040e-12
		,1.8233496190e-12
		,2.3251146760e-12
		,2.9786648340e-12
		,3.8305055070e-12
		,4.9417753260e-12
		,6.3897294560e-12
		,8.2752818260e-12
		,1.0738413450e-11
		,1.3959647500e-11
		,1.8175476450e-11
		,2.3696522890e-11
		,3.0931672970e-11
		,4.0419334150e-11
		,5.2868302340e-11
		,6.9212470560e-11
		,9.0682938030e-11
		,1.1890325420e-10
		,1.5601521180e-10
		,2.0484584950e-10
		,2.6909793180e-10
		,3.5369404550e-10
		,4.6515438480e-10
		,6.1208027540e-10
		,8.0584632110e-10
		,1.0615014100e-09
		////////////////////////////////
		,2.8196669760e-17
		,5.6489902950e-10
		,9.6434428760e-10
		,1.2495216690e-09
		,1.4558121570e-09
		,1.6076672230e-09
		,1.7219811900e-09
		,1.8104235920e-09
		,1.8810524710e-09
		,1.9394292740e-09
		,1.9893895780e-09
		,2.0335762540e-09
		,2.0738070390e-09
		,2.1113293300e-09
		,2.1469954260e-09
		,2.1813840940e-09
		,2.2148844540e-09
		,2.2477536390e-09
		,2.2801571950e-09
		,2.3121964000e-09
		,2.3439278730e-09
		,2.3753765190e-09
		,2.4065450140e-09
		,2.4374200040e-09
		,2.4679767230e-09
		,2.4981822380e-09
		,2.5279975760e-09
		,2.5573799530e-09
		,2.5862843350e-09
		,2.6146655530e-09
		,2.6424799820e-09
		,2.6696882760e-09
		,2.6962577120e-09
		,2.7221655880e-09
		,2.7474022320e-09
		,2.7719739290e-09
		,2.7959049950e-09
		,2.8192382210e-09
		,2.8420326090e-09
		,2.8643597450e-09
		,2.8862980400e-09
		,2.9079267830e-09
		,2.9293212680e-09
		,2.9505493810e-09
		,2.9716695500e-09
		,2.9927305620e-09
		,3.0137720200e-09
		,3.0348256640e-09
		,3.0559162430e-09
		,3.0770633150e-09
		,3.0982819760e-09
		,3.1195837770e-09
		,3.1409778630e-09
		,3.1624711480e-09
		,3.1840691430e-09
		,3.2057760830e-09
		,3.2275953530e-09
		,3.2495295810e-09
		,3.2715809090e-09
		,3.2937510920e-09
		,3.3160414730e-09
		,3.3384532740e-09
		,3.3609872750e-09
		,3.3836444370e-09
		,3.4064252770e-09
		,3.4293304170e-09
		,3.4523601890e-09
		,3.4755150690e-09
		,3.4987953160e-09
		,3.5222011830e-09
		,3.5457329520e-09
		,3.5693907570e-09
		,3.5931747500e-09
		,3.6170850650e-09
		,3.6411218000e-09
		,3.6652850810e-09
		,3.6895750680e-09
		,3.7139917160e-09
		,3.7385351830e-09
		,3.7632056150e-09
		,3.7880030150e-09
		,3.8129275970e-09
		,3.8379794650e-09
		,3.8631589430e-09
		,3.8884661610e-09
		,3.9139014920e-09
		,3.9394652490e-09
		,3.9651579750e-09
		,3.9909801120e-09
		,4.0169325010e-09
		,4.0430157580e-09
		,4.0692309570e-09
		,4.0955790640e-09
		,4.1220616030e-09
		,4.1486801070e-09
		,4.1754366610e-09
		,4.2023335780e-09
		,4.2293737830e-09
		,4.2565609620e-09
		,4.2838996150e-09
		,4.3113866120e-09
		,4.3390331730e-09
		,4.3668466050e-09
		,4.3948362350e-09
		,4.4230139160e-09
		,4.4513951920e-09
		,4.4800001800e-09
		,4.5088539420e-09
		,4.5379918600e-09
		,4.5674598710e-09
		,4.5973120950e-09
		,4.6275349920e-09
		,4.6582668870e-09
		,4.6896170720e-09
		,4.7217289790e-09
		,4.7547898990e-09
		,4.7890461870e-09
		,4.8248211850e-09
		,4.8625294510e-09
		,4.9027357920e-09
		,4.9461754740e-09
		////////////////////////////////
		,-1.2949829390e-17
		,5.7281311030e-10
		,9.7842498940e-10
		,1.2685286720e-09
		,1.4788741920e-09
		,1.6341818340e-09
		,1.7515420160e-09
		,1.8427683090e-09
		,1.9160249360e-09
		,1.9769527260e-09
		,2.0294479400e-09
		,2.0762003150e-09
		,2.1190655740e-09
		,2.1593224520e-09
		,2.1978506320e-09
		,2.2352534290e-09
		,2.2719426300e-09
		,2.3081971220e-09
		,2.3442030390e-09
		,2.3800817830e-09
		,2.4159093810e-09
		,2.4517292440e-09
		,2.4875620270e-09
		,2.5234112230e-09
		,2.5592684230e-09
		,2.5951156630e-09
		,2.6309283530e-09
		,2.6666763310e-09
		,2.7023254520e-09
		,2.7378379190e-09
		,2.7731732820e-09
		,2.8082882190e-09
		,2.8431370300e-09
		,2.8776717260e-09
		,2.9118423960e-09
		,2.9455974230e-09
		,2.9788845630e-09
		,3.0116517520e-09
		,3.0438487780e-09
		,3.0754287450e-09
		,3.1063504250e-09
		,3.1365806740e-09
		,3.1660976880e-09
		,3.1948938900e-09
		,3.2229791930e-09
		,3.2503826820e-09
		,3.2771529910e-09
		,3.3033559130e-09
		,3.3290701030e-09
		,3.3543809300e-09
		,3.3793746330e-09
		,3.4041323370e-09
		,3.4287271280e-09
		,3.4532216780e-09
		,3.4776682020e-09
		,3.5021090690e-09
		,3.5265779940e-09
		,3.5511013390e-09
		,3.5756997590e-09
		,3.6003889720e-09
		,3.6251813090e-09
		,3.6500860860e-09
		,3.6751105930e-09
		,3.7002604270e-09
		,3.7255399240e-09
		,3.7509525410e-09
		,3.7765008840e-09
		,3.8021871440e-09
		,3.8280129210e-09
		,3.8539796200e-09
		,3.8800882520e-09
		,3.9063397160e-09
		,3.9327348290e-09
		,3.9592740520e-09
		,3.9859578460e-09
		,4.0127866050e-09
		,4.0397607450e-09
		,4.0668804730e-09
		,4.0941460670e-09
		,4.1215576410e-09
		,4.1491153950e-09
		,4.1768194830e-09
		,4.2046699750e-09
		,4.2326669430e-09
		,4.2608105550e-09
		,4.2891008790e-09
		,4.3175380480e-09
		,4.3461222100e-09
		,4.3748535170e-09
		,4.4037322570e-09
		,4.4327585250e-09
		,4.4619326690e-09
		,4.4912550420e-09
		,4.5207260650e-09
		,4.5503462160e-09
		,4.5801162720e-09
		,4.6100369450e-09
		,4.6401092610e-09
		,4.6703342890e-09
		,4.7007132360e-09
		,4.7312474840e-09
		,4.7619386730e-09
		,4.7927887140e-09
		,4.8237998620e-09
		,4.8549746560e-09
		,4.8863160970e-09
		,4.9178241070e-09
		,4.9495035060e-09
		,4.9813595680e-09
		,5.0133974240e-09
		,5.0456234690e-09
		,5.0780458360e-09
		,5.1106743780e-09
		,5.1435217540e-09
		,5.1766045080e-09
		,5.2099440650e-09
		,5.2435689120e-09
		,5.2774813000e-09
		,5.3117220790e-09
		,5.3463489750e-09
		,5.3814232760e-09
		////////////////////////////////
		,-3.9163974660e-18
		,5.7948783070e-10
		,9.9027554560e-10
		,1.2844908830e-09
		,1.4981991880e-09
		,1.6563490360e-09
		,1.7761964250e-09
		,1.8696752200e-09
		,1.9450372200e-09
		,2.0079874280e-09
		,2.0624696080e-09
		,2.1112093630e-09
		,2.1560898320e-09
		,2.1984116740e-09
		,2.2390727480e-09
		,2.2786921630e-09
		,2.3176961430e-09
		,2.3563773180e-09
		,2.3949355890e-09
		,2.4335063910e-09
		,2.4721799350e-09
		,2.5110149040e-09
		,2.5500474310e-09
		,2.5892973390e-09
		,2.6287725550e-09
		,2.6684719350e-09
		,2.7083872860e-09
		,2.7485048290e-09
		,2.7888058810e-09
		,2.8292678510e-09
		,2.8698646290e-09
		,2.9105669680e-09
		,2.9513430210e-09
		,2.9921586140e-09
		,3.0329775950e-09
		,3.0737621110e-09
		,3.1144723980e-09
		,3.1550672500e-09
		,3.1955034140e-09
		,3.2357356460e-09
		,3.2757163740e-09
		,3.3153956760e-09
		,3.3547211860e-09
		,3.3936386810e-09
		,3.4320925920e-09
		,3.4700270310e-09
		,3.5073869270e-09
		,3.5441196100e-09
		,3.5801761840e-09
		,3.6155142060e-09
		,3.6501002190e-09
		,3.6839129600e-09
		,3.7169468600e-09
		,3.7492148920e-09
		,3.7807506060e-09
		,3.8116084970e-09
		,3.8418613290e-09
		,3.8715952120e-09
		,3.9009036910e-09
		,3.9298807060e-09
		,3.9586149390e-09
		,3.9871860830e-09
		,4.0156624700e-09
		,4.0441008440e-09
		,4.0725471890e-09
		,4.1010379970e-09
		,4.1296017100e-09
		,4.1582606230e-09
		,4.1870316350e-09
		,4.2159278420e-09
		,4.2449592070e-09
		,4.2741335300e-09
		,4.3034565530e-09
		,4.3329329030e-09
		,4.3625659660e-09
		,4.3923585260e-09
		,4.4223125940e-09
		,4.4524298640e-09
		,4.4827117890e-09
		,4.5131593980e-09
		,4.5437736090e-09
		,4.5745551520e-09
		,4.6055044170e-09
		,4.6366219090e-09
		,4.6679081150e-09
		,4.6993632980e-09
		,4.7309876940e-09
		,4.7627814840e-09
		,4.7947449170e-09
		,4.8268780880e-09
		,4.8591812180e-09
		,4.8916543290e-09
		,4.9242977180e-09
		,4.9571114750e-09
		,4.9900957990e-09
		,5.0232510820e-09
		,5.0565775040e-09
		,5.0900754160e-09
		,5.1237453320e-09
		,5.1575875770e-09
		,5.1916029800e-09
		,5.2257920450e-09
		,5.2601556540e-09
		,5.2946946800e-09
		,5.3294102690e-09
		,5.3643035250e-09
		,5.3993758520e-09
		,5.4346288160e-09
		,5.4700641990e-09
		,5.5056838890e-09
		,5.5414902140e-09
		,5.5774857330e-09
		,5.6136721440e-09
		,5.6500519680e-09
		,5.6866293600e-09
		,5.7234081080e-09
		,5.7603925920e-09
		,5.7975877940e-09
		,5.8349999020e-09
		,5.8726356400e-09
		,5.9105036080e-09
		////////////////////////////////
		,-3.6030992390e-18
		,7.6100518110e-11
		,1.3702529340e-10
		,1.8736957430e-10
		,2.3052222190e-10
		,2.6896856140e-10
		,3.0453812400e-10
		,3.3858505900e-10
		,3.7210104860e-10
		,4.0580032920e-10
		,4.4021001490e-10
		,4.7576166500e-10
		,5.1284813120e-10
		,5.5182779600e-10
		,5.9301282490e-10
		,6.3668213710e-10
		,6.8311002450e-10
		,7.3257564150e-10
		,7.8535387950e-10
		,8.4174276710e-10
		,9.0206058810e-10
		,9.6659645510e-10
		,1.0356053320e-09
		,1.1093067710e-09
		,1.1878916470e-09
		,1.2715436100e-09
		,1.3604794110e-09
		,1.4550153830e-09
		,1.5556297100e-09
		,1.6629322650e-09
		,1.7776290090e-09
		,1.9005038070e-09
		,2.0324377610e-09
		,2.1744404870e-09
		,2.3277384480e-09
		,2.4938720450e-09
		,2.6747611800e-09
		,2.8728924170e-09
		,3.0916722510e-09
		,3.3357650320e-09
		,3.6101831850e-09
		,3.9251670970e-09
		,4.2951927320e-09
		,4.7394567800e-09
		,5.2827603710e-09
		,5.9544682250e-09
		,6.8067336110e-09
		,7.9076698910e-09
		,9.3422249680e-09
		,1.1213496270e-08
		,1.3670254670e-08
		,1.6942053000e-08
		,2.1315876000e-08
		,2.7187966060e-08
		,3.5087876240e-08
		,4.5734624630e-08
		,6.0092912830e-08
		,7.9460458160e-08
		,1.0557132880e-07
		,1.4072982730e-07
		,1.8795651910e-07
		,2.5125618590e-07
		,3.3579629930e-07
		,4.4818767530e-07
		,5.9675461230e-07
		,7.9178244730e-07
		,1.0456742490e-06
		,1.3729326010e-06
		,1.7904484080e-06
		,2.3169321140e-06
		,2.9726275120e-06
		,3.7788064240e-06
		,4.7572073150e-06
		,5.9294853750e-06
		,7.3167336610e-06
		,8.9391169490e-06
		,1.0815636690e-05
		,1.2964024160e-05
		,1.5400743680e-05
		,1.8122403510e-05
		,2.1139679490e-05
		,2.4472693950e-05
		,2.8130768400e-05
		,3.2087123780e-05
		,3.6376438390e-05
		,4.0982963070e-05
		,4.5805168030e-05
		,5.0934777970e-05
		,5.6279501000e-05
		,6.1699796540e-05
		,6.7252307190e-05
		,7.3108539240e-05
		,7.9273519170e-05
		,8.5752955680e-05
		,9.2553266450e-05
		,9.9681584780e-05
		,1.0714582770e-04
		,1.1495463130e-04
		,1.2311734460e-04
		,1.3164389850e-04
		,1.4054494860e-04
		,1.4981525740e-04
		,1.5947398290e-04
		,1.6925177100e-04
		,1.7934388440e-04
		,1.8972313590e-04
		,2.0021993150e-04
		,2.1062974220e-04
		,2.2076790350e-04
		,2.3119617520e-04
		,2.4192319740e-04
		,2.5296128440e-04
		,2.6432672260e-04
		,2.7604009550e-04
		,2.8812652430e-04
		,3.0061566280e-04
		,3.1338398660e-04
		,3.2589649730e-04
		,3.3818318410e-04
		,3.5051798900e-04
		,3.6186721200e-04
		////////////////////////////////
		,-1.8745846390e-17
		,3.4828802450e-10
		,6.2956076110e-10
		,8.6164920910e-10
		,1.0580330420e-09
		,1.2292535380e-09
		,1.3835950580e-09
		,1.5272539600e-09
		,1.6645512760e-09
		,1.7982889930e-09
		,1.9302016300e-09
		,2.0614554500e-09
		,2.1930422870e-09
		,2.3259391940e-09
		,2.4611266270e-09
		,2.5995909730e-09
		,2.7422705150e-09
		,2.8899320960e-09
		,3.0430472020e-09
		,3.2017151250e-09
		,3.3658032260e-09
		,3.5353052140e-09
		,3.7105100600e-09
		,3.8917710190e-09
		,4.0792741250e-09
		,4.2732005510e-09
		,4.4738809280e-09
		,4.6816859220e-09
		,4.8969672900e-09
		,5.1200437090e-09
		,5.3512305970e-09
		,5.5908475160e-09
		,5.8392009870e-09
		,6.0965777010e-09
		,6.3632560130e-09
		,6.6395181000e-09
		,6.9256700100e-09
		,7.2220639500e-09
		,7.5291551540e-09
		,7.8475538340e-09
		,8.1780926840e-09
		,8.5219295180e-09
		,8.8806830610e-09
		,9.2566228250e-09
		,9.6529269500e-09
		,1.0074050070e-08
		,1.0524149760e-08
		,1.1012857680e-08
		,1.1551657000e-08
		,1.2157175930e-08
		,1.2851643430e-08
		,1.3665970240e-08
		,1.4643366100e-08
		,1.5842803990e-08
		,1.7338549470e-08
		,1.9222471940e-08
		,2.1570618400e-08
		,2.4601914440e-08
		,2.8539279070e-08
		,3.3704186500e-08
		,4.0513496900e-08
		,4.9532093910e-08
		,6.1512656160e-08
		,7.7460200270e-08
		,9.8702837040e-08
		,1.2700783570e-07
		,1.6469331360e-07
		,2.1479952260e-07
		,2.8116992580e-07
		,3.6866536570e-07
		,4.8386985690e-07
		,6.3495294290e-07
		,8.3144428740e-07
		,1.0856453330e-06
		,1.4112477910e-06
		,1.8260496030e-06
		,2.3495321140e-06
		,3.0033116580e-06
		,3.8106203090e-06
		,4.7954612030e-06
		,5.9811267700e-06
		,7.3909760970e-06
		,9.0465465470e-06
		,1.0966760680e-05
		,1.3167747410e-05
		,1.5662718400e-05
		,1.8462083880e-05
		,2.1573749960e-05
		,2.5003529340e-05
		,2.8755601440e-05
		,3.2832979500e-05
		,3.7237936090e-05
		,4.1972374700e-05
		,4.7038138330e-05
		,5.2437271540e-05
		,5.8172194970e-05
		,6.4245842340e-05
		,7.0661743850e-05
		,7.7424064900e-05
		,8.4537604510e-05
		,9.2003277340e-05
		,9.9795201000e-05
		,1.0786310540e-04
		,1.1627432330e-04
		,1.2503238070e-04
		,1.3391674030e-04
		,1.4313180420e-04
		,1.5268817980e-04
		,1.6259266530e-04
		,1.7280522480e-04
		,1.8315442000e-04
		,1.9317140180e-04
		,2.0317396030e-04
		,2.1348717860e-04
		,2.2412944290e-04
		,2.3512374110e-04
		,2.4649723660e-04
		,2.5828011200e-04
		,2.7050328160e-04
		,2.8201359150e-04
		,2.9330786720e-04
		////////////////////////////////
		,1.8849939630e-17
		,1.4092379270e-09
		,2.4977970080e-09
		,3.3544834560e-09
		,4.0443289300e-09
		,4.6163658970e-09
		,5.1052064700e-09
		,5.5371606290e-09
		,5.9323424750e-09
		,6.3035345640e-09
		,6.6587189520e-09
		,7.0035181790e-09
		,7.3420646990e-09
		,7.6767195690e-09
		,8.0085013130e-09
		,8.3380237060e-09
		,8.6657469470e-09
		,8.9919020460e-09
		,9.3167498160e-09
		,9.6407630980e-09
		,9.9646057810e-09
		,1.0288954100e-08
		,1.0614216500e-08
		,1.0940362940e-08
		,1.1266875000e-08
		,1.1592760280e-08
		,1.1916636440e-08
		,1.2236905190e-08
		,1.2551964480e-08
		,1.2860368780e-08
		,1.3161071290e-08
		,1.3453958370e-08
		,1.3739821920e-08
		,1.4019587870e-08
		,1.4293925150e-08
		,1.4563404330e-08
		,1.4828839690e-08
		,1.5091372470e-08
		,1.5352160250e-08
		,1.5612093490e-08
		,1.5871819490e-08
		,1.6131876350e-08
		,1.6392730350e-08
		,1.6654784400e-08
		,1.6918421210e-08
		,1.7184047300e-08
		,1.7452140380e-08
		,1.7723322790e-08
		,1.7998465720e-08
		,1.8278829920e-08
		,1.8566242800e-08
		,1.8863316860e-08
		,1.9172183210e-08
		,1.9497817930e-08
		,1.9847069900e-08
		,2.0228672430e-08
		,2.0654535860e-08
		,2.1140918010e-08
		,2.1710012490e-08
		,2.2392117390e-08
		,2.3228598370e-08
		,2.4275943590e-08
		,2.5541851060e-08
		,2.7136134590e-08
		,2.9179985280e-08
		,3.1824257920e-08
		,3.5269970620e-08
		,3.9783165870e-08
		,4.5714684330e-08
		,5.3539937510e-08
		,6.3882823750e-08
		,7.7563775790e-08
		,9.5679237060e-08
		,1.1965902250e-07
		,1.5139107540e-07
		,1.9333644480e-07
		,2.4853803340e-07
		,3.2121177430e-07
		,4.1662158370e-07
		,5.4144976480e-07
		,7.0408411970e-07
		,9.1492291370e-07
		,1.1866650040e-06
		,1.5345529700e-06
		,1.9765242740e-06
		,2.5332194350e-06
		,3.2277991770e-06
		,4.0855394280e-06
		,5.1332014810e-06
		,6.3982140310e-06
		,7.9077436060e-06
		,9.6877593770e-06
		,1.1762202380e-05
		,1.4152353190e-05
		,1.6876453290e-05
		,1.9944428000e-05
		,2.3360817760e-05
		,2.7133651800e-05
		,3.1270962240e-05
		,3.5774640420e-05
		,4.0644776940e-05
		,4.5880114440e-05
		,5.1478475180e-05
		,5.7437114500e-05
		,6.3753028990e-05
		,7.0423218700e-05
		,7.7429203030e-05
		,8.4770801330e-05
		,9.2453682610e-05
		,1.0047641730e-04
		,1.0883860050e-04
		,1.1754093750e-04
		,1.2658540860e-04
		,1.3597544060e-04
		,1.4571361140e-04
		,1.5579269810e-04
		,1.6620294300e-04
		,1.7658051310e-04
		,1.8702606040e-04
		,1.9771384630e-04
		,2.0853065220e-04
		////////////////////////////////
		,1.4829279180e-17
		,3.5973162100e-09
		,6.2121822860e-09
		,8.1309384930e-09
		,9.5590739820e-09
		,1.0644104640e-08
		,1.1489218980e-08
		,1.2166364210e-08
		,1.2725882830e-08
		,1.3201642000e-08
		,1.3618660680e-08
		,1.3996661380e-08
		,1.4348789810e-08
		,1.4683091590e-08
		,1.5004270640e-08
		,1.5315176000e-08
		,1.5615595830e-08
		,1.5904697630e-08
		,1.6184829090e-08
		,1.6459510230e-08
		,1.6730884340e-08
		,1.6999831350e-08
		,1.7266472800e-08
		,1.7530618410e-08
		,1.7791853770e-08
		,1.8049383940e-08
		,1.8302450910e-08
		,1.8550678420e-08
		,1.8793756190e-08
		,1.9031504960e-08
		,1.9264053560e-08
		,1.9491735440e-08
		,1.9715050550e-08
		,1.9934588280e-08
		,2.0150926340e-08
		,2.0364554480e-08
		,2.0575839240e-08
		,2.0785054920e-08
		,2.0992403600e-08
		,2.1198008300e-08
		,2.1401930810e-08
		,2.1604186010e-08
		,2.1804790860e-08
		,2.2003838330e-08
		,2.2201483080e-08
		,2.2397845860e-08
		,2.2592956510e-08
		,2.2786786640e-08
		,2.2979346060e-08
		,2.3170737160e-08
		,2.3361105390e-08
		,2.3550598560e-08
		,2.3739397480e-08
		,2.3927760570e-08
		,2.4116063640e-08
		,2.4304900250e-08
		,2.4495223520e-08
		,2.4688455080e-08
		,2.4885960750e-08
		,2.5089689350e-08
		,2.5302966600e-08
		,2.5529470870e-08
		,2.5774068930e-08
		,2.6043359400e-08
		,2.6346404000e-08
		,2.6695692290e-08
		,2.7108268360e-08
		,2.7607261220e-08
		,2.8206683300e-08
		,2.8931415170e-08
		,2.9839292950e-08
		,3.0990820060e-08
		,3.2466582370e-08
		,3.4373698930e-08
		,3.6854611490e-08
		,4.0098651030e-08
		,4.4357316070e-08
		,4.9963946690e-08
		,5.7360411030e-08
		,6.7132922020e-08
		,8.0055574780e-08
		,9.7147476570e-08
		,1.1975159690e-07
		,1.4962880300e-07
		,1.8893482800e-07
		,2.4072528030e-07
		,3.0883894620e-07
		,3.9818853640e-07
		,5.1502059530e-07
		,6.6718189830e-07
		,8.6444833340e-07
		,1.1188097970e-06
		,1.4447298750e-06
		,1.8593412800e-06
		,2.3825143860e-06
		,3.0367532280e-06
		,3.8468801950e-06
		,4.8394927030e-06
		,6.0422102610e-06
		,7.4827697690e-06
		,9.1880618800e-06
		,1.1183217020e-05
		,1.3490844140e-05
		,1.6130497390e-05
		,1.9118403980e-05
		,2.2467444120e-05
		,2.6187342810e-05
		,3.0282896610e-05
		,3.4758745480e-05
		,3.9617304580e-05
		,4.4858942020e-05
		,5.0482805300e-05
		,5.6487172430e-05
		,6.2869739470e-05
		,6.9627865300e-05
		,7.6758767670e-05
		,8.4259682650e-05
		,9.2112780190e-05
		,1.0032282280e-04
		,1.0888883290e-04
		,1.1780743540e-04
		////////////////////////////////
		,-2.0416770220e-17
		,5.2850284680e-09
		,9.0176635020e-09
		,1.1672039030e-08
		,1.3578035790e-08
		,1.4964658920e-08
		,1.5991123470e-08
		,1.6767940060e-08
		,1.7371290570e-08
		,1.7853777570e-08
		,1.8251747370e-08
		,1.8590021410e-08
		,1.8885902690e-08
		,1.9151438930e-08
		,1.9394940420e-08
		,1.9622354550e-08
		,1.9838272030e-08
		,2.0045983830e-08
		,2.0247683530e-08
		,2.0444983280e-08
		,2.0639095600e-08
		,2.0830795240e-08
		,2.1020586150e-08
		,2.1208854340e-08
		,2.1395822780e-08
		,2.1581634840e-08
		,2.1766343850e-08
		,2.1949895240e-08
		,2.2132157510e-08
		,2.2313022120e-08
		,2.2492487920e-08
		,2.2670709920e-08
		,2.2847918710e-08
		,2.3024306760e-08
		,2.3200012350e-08
		,2.3375162720e-08
		,2.3549901080e-08
		,2.3724374820e-08
		,2.3898733530e-08
		,2.4073112260e-08
		,2.4247609010e-08
		,2.4422292170e-08
		,2.4597205270e-08
		,2.4772370100e-08
		,2.4947786400e-08
		,2.5123421020e-08
		,2.5299205310e-08
		,2.5475073250e-08
		,2.5651037250e-08
		,2.5827192070e-08
		,2.6003646050e-08
		,2.6180482260e-08
		,2.6357759460e-08
		,2.6535522620e-08
		,2.6713812390e-08
		,2.6892672190e-08
		,2.7072153480e-08
		,2.7252321690e-08
		,2.7433261820e-08
		,2.7615085260e-08
		,2.7797937140e-08
		,2.7982008230e-08
		,2.8167554860e-08
		,2.8354932030e-08
		,2.8544512350e-08
		,2.8736576580e-08
		,2.8932478150e-08
		,2.9133728480e-08
		,2.9342404750e-08
		,2.9561261150e-08
		,2.9793940680e-08
		,3.0045304050e-08
		,3.0321894490e-08
		,3.0632567100e-08
		,3.0987515790e-08
		,3.1388269170e-08
		,3.1860726860e-08
		,3.2428297940e-08
		,3.3122125110e-08
		,3.3983642970e-08
		,3.5067974190e-08
		,3.6448441390e-08
		,3.8222551890e-08
		,4.0519928750e-08
		,4.3512809840e-08
		,4.7429915180e-08
		,5.2574733500e-08
		,5.9349561710e-08
		,6.8287007210e-08
		,8.0091249240e-08
		,9.5691473800e-08
		,1.1631108030e-07
		,1.4343449830e-07
		,1.7921025650e-07
		,2.2635521230e-07
		,2.8836836820e-07
		,3.6974865470e-07
		,4.7623113140e-07
		,6.1506009930e-07
		,7.9528384780e-07
		,1.0280566280e-06
		,1.3269198890e-06
		,1.7080268380e-06
		,2.1902611840e-06
		,2.7952073810e-06
		,3.5469259990e-06
		,4.4714977590e-06
		,5.5963568610e-06
		,6.9494478990e-06
		,8.5582872030e-06
		,1.0449032190e-05
		,1.2645663240e-05
		,1.5169364370e-05
		,1.8038151040e-05
		,2.1266750180e-05
		,2.4866702900e-05
		,2.8846636160e-05
		,3.3212650250e-05
		,3.7968754250e-05
		,4.3117304840e-05
		,4.8651039610e-05
		////////////////////////////////
		,-1.3158694860e-17
		,6.3691630640e-09
		,1.0806911660e-08
		,1.3913940030e-08
		,1.6105067340e-08
		,1.7666124970e-08
		,1.8793795950e-08
		,1.9623270970e-08
		,2.0247545770e-08
		,2.0730863290e-08
		,2.1117392990e-08
		,2.1437423500e-08
		,2.1711737470e-08
		,2.1954595200e-08
		,2.2175782780e-08
		,2.2382021620e-08
		,2.2577930450e-08
		,2.2766656610e-08
		,2.2950302690e-08
		,2.3130227790e-08
		,2.3307271530e-08
		,2.3481972620e-08
		,2.3654815100e-08
		,2.3826342340e-08
		,2.3997067560e-08
		,2.4167398160e-08
		,2.4337625380e-08
		,2.4507955920e-08
		,2.4678534270e-08
		,2.4849453270e-08
		,2.5020781030e-08
		,2.5192570560e-08
		,2.5364856100e-08
		,2.5537663170e-08
		,2.5711013470e-08
		,2.5884927480e-08
		,2.6059422950e-08
		,2.6234516550e-08
		,2.6410222290e-08
		,2.6586551260e-08
		,2.6763512170e-08
		,2.6941113870e-08
		,2.7119365770e-08
		,2.7298276530e-08
		,2.7477853100e-08
		,2.7658101350e-08
		,2.7839026660e-08
		,2.8020634260e-08
		,2.8202928470e-08
		,2.8385913370e-08
		,2.8569594430e-08
		,2.8753978470e-08
		,2.8939073330e-08
		,2.9124887060e-08
		,2.9311428090e-08
		,2.9498705900e-08
		,2.9686730080e-08
		,2.9875510540e-08
		,3.0065058570e-08
		,3.0255387620e-08
		,3.0446513530e-08
		,3.0638454630e-08
		,3.0831232250e-08
		,3.1024871690e-08
		,3.1219403200e-08
		,3.1414862660e-08
		,3.1611289920e-08
		,3.1808720610e-08
		,3.2007174220e-08
		,3.2206670850e-08
		,3.2407349670e-08
		,3.2609298640e-08
		,3.2813356470e-08
		,3.3020280460e-08
		,3.3230946860e-08
		,3.3446439120e-08
		,3.3668167920e-08
		,3.3898014320e-08
		,3.4138512520e-08
		,3.4393093710e-08
		,3.4666413910e-08
		,3.4959454770e-08
		,3.5280155850e-08
		,3.5638798620e-08
		,3.6047489650e-08
		,3.6522322700e-08
		,3.7084689490e-08
		,3.7763029610e-08
		,3.8595149880e-08
		,3.9631315020e-08
		,4.0938339390e-08
		,4.2605020060e-08
		,4.4749338880e-08
		,4.7527989270e-08
		,5.1148969610e-08
		,5.5888197320e-08
		,6.2111378590e-08
		,7.0302719990e-08
		,8.1102507980e-08
		,9.5356104340e-08
		,1.1407468010e-07
		,1.3875623690e-07
		,1.7130423990e-07
		,2.1418039050e-07
		,2.7057460970e-07
		,3.4459512730e-07
		,4.4149398070e-07
		,5.6792606000e-07
		,7.3223623870e-07
		,9.4475971250e-07
		,1.2181140030e-06
		,1.5674477800e-06
		,2.0106039700e-06
		,2.5681488940e-06
		,3.2632208840e-06
		,4.1211649310e-06
		,5.1689460660e-06
		,6.4343697630e-06
		,7.9451750770e-06
		,9.7280965960e-06
		,1.1807999280e-05
		////////////////////////////////
		,1.3210571730e-17
		,7.0524090320e-09
		,1.1974163000e-08
		,1.5422641510e-08
		,1.7853356150e-08
		,1.9581635500e-08
		,2.0825509370e-08
		,2.1735573610e-08
		,2.2415751430e-08
		,2.2937702890e-08
		,2.3350804160e-08
		,2.3689085230e-08
		,2.3976019390e-08
		,2.4227759080e-08
		,2.4455412000e-08
		,2.4666624050e-08
		,2.4866662670e-08
		,2.5059157650e-08
		,2.5246615810e-08
		,2.5430773690e-08
		,2.5612831690e-08
		,2.5793624200e-08
		,2.5973745970e-08
		,2.6153612100e-08
		,2.6333510500e-08
		,2.6513643190e-08
		,2.6694151970e-08
		,2.6875140190e-08
		,2.7056687600e-08
		,2.7238851310e-08
		,2.7421671440e-08
		,2.7605175190e-08
		,2.7789377520e-08
		,2.7974278530e-08
		,2.8159857740e-08
		,2.8346061100e-08
		,2.8532778520e-08
		,2.8719820380e-08
		,2.8906982000e-08
		,2.9094251020e-08
		,2.9281870240e-08
		,2.9470120860e-08
		,2.9659188910e-08
		,2.9849176580e-08
		,3.0040138510e-08
		,3.0232104380e-08
		,3.0425090730e-08
		,3.0619107070e-08
		,3.0814158620e-08
		,3.1010248020e-08
		,3.1207376760e-08
		,3.1405545160e-08
		,3.1604753040e-08
		,3.1804999590e-08
		,3.2006283660e-08
		,3.2208604100e-08
		,3.2411960410e-08
		,3.2616351970e-08
		,3.2821778330e-08
		,3.3028239380e-08
		,3.3235735460e-08
		,3.3444267420e-08
		,3.3653837110e-08
		,3.3864447040e-08
		,3.4076101120e-08
		,3.4288804480e-08
		,3.4502564610e-08
		,3.4717391040e-08
		,3.4933296410e-08
		,3.5150297250e-08
		,3.5368415130e-08
		,3.5587678280e-08
		,3.5808123340e-08
		,3.6029798830e-08
		,3.6252768490e-08
		,3.6477116740e-08
		,3.6702955550e-08
		,3.6930310740e-08
		,3.7159385210e-08
		,3.7390438850e-08
		,3.7623777930e-08
		,3.7859812240e-08
		,3.8099092760e-08
		,3.8342361810e-08
		,3.8590621360e-08
		,3.8845225740e-08
		,3.9108008520e-08
		,3.9380356040e-08
		,3.9663707020e-08
		,3.9962864660e-08
		,4.0282583100e-08
		,4.0629168290e-08
		,4.1010989260e-08
		,4.1439160240e-08
		,4.1928438110e-08
		,4.2498422740e-08
		,4.3175150030e-08
		,4.3993207120e-08
		,4.4998541480e-08
		,4.6252179940e-08
		,4.7835180590e-08
		,4.9855187390e-08
		,5.2455079560e-08
		,5.5824448820e-08
		,6.0214750470e-08
		,6.5959216050e-08
		,7.3499103490e-08
		,8.3418121010e-08
		,9.6400313840e-08
		,1.1348627990e-07
		,1.3600417150e-07
		,1.6567279530e-07
		,2.0473297500e-07
		,2.5609242480e-07
		,3.2350284610e-07
		,4.1177182260e-07
		,5.2700950040e-07
		,6.7690570340e-07
		,8.7102671000e-07
		,1.1211123710e-06
		,1.4413441740e-06
		////////////////////////////////
		,5.2046617400e-20
		,7.4573108460e-09
		,1.2700931290e-08
		,1.6410399100e-08
		,1.9056642280e-08
		,2.0965588870e-08
		,2.2362569980e-08
		,2.3403245480e-08
		,2.4195099650e-08
		,2.4812317270e-08
		,2.5305945990e-08
		,2.5710958070e-08
		,2.6052401480e-08
		,2.6349117510e-08
		,2.6614376130e-08
		,2.6857360620e-08
		,2.7084557250e-08
		,2.7300608150e-08
		,2.7508856990e-08
		,2.7711720060e-08
		,2.7910944390e-08
		,2.8107793300e-08
		,2.8303181830e-08
		,2.8497772780e-08
		,2.8692050010e-08
		,2.8886369290e-08
		,2.9080991080e-08
		,2.9276107470e-08
		,2.9471861400e-08
		,2.9668360030e-08
		,2.9865684320e-08
		,3.0063896030e-08
		,3.0263041450e-08
		,3.0463157150e-08
		,3.0664274070e-08
		,3.0866418720e-08
		,3.1069612440e-08
		,3.1273872140e-08
		,3.1479211430e-08
		,3.1685641830e-08
		,3.1893172910e-08
		,3.2101812900e-08
		,3.2311568740e-08
		,3.2522446200e-08
		,3.2734449280e-08
		,3.2947580480e-08
		,3.3161845290e-08
		,3.3377247620e-08
		,3.3593789810e-08
		,3.3811473720e-08
		,3.4030301340e-08
		,3.4250274370e-08
		,3.4471393660e-08
		,3.4693659980e-08
		,3.4917073680e-08
		,3.5141635100e-08
		,3.5367344170e-08
		,3.5594200980e-08
		,3.5822205200e-08
		,3.6051356590e-08
		,3.6281654390e-08
		,3.6513098290e-08
		,3.6745688720e-08
		,3.6979426110e-08
		,3.7214310910e-08
		,3.7450343940e-08
		,3.7687526290e-08
		,3.7925859320e-08
		,3.8165345250e-08
		,3.8405986720e-08
		,3.8647787260e-08
		,3.8890751510e-08
		,3.9134885050e-08
		,3.9380195030e-08
		,3.9626690290e-08
		,3.9874381820e-08
		,4.0123283170e-08
		,4.0373411240e-08
		,4.0624786970e-08
		,4.0877436740e-08
		,4.1131393950e-08
		,4.1386701110e-08
		,4.1643412880e-08
		,4.1901558310e-08
		,4.2161197160e-08
		,4.2422462420e-08
		,4.2685487080e-08
		,4.2950446040e-08
		,4.3217570650e-08
		,4.3487168450e-08
		,4.3759650050e-08
		,4.4035564700e-08
		,4.4315650420e-08
		,4.4600872590e-08
		,4.4891125780e-08
		,4.5188636280e-08
		,4.5495298380e-08
		,4.5813616270e-08
		,4.6146904180e-08
		,4.6499550390e-08
		,4.6877364290e-08
		,4.7288052050e-08
		,4.7741836770e-08
		,4.8252277190e-08
		,4.8837364830e-08
		,4.9520973680e-08
		,5.0334800360e-08
		,5.1320916690e-08
		,5.2535170750e-08
		,5.4051692220e-08
		,5.5968863890e-08
		,5.8417210070e-08
		,6.1569852840e-08
		,6.5656417800e-08
		,7.0981162810e-08
		,7.7947154180e-08
		,8.7014088620e-08
		,9.8902835150e-08
		,1.1453820510e-07
		,1.3511420030e-07
		,1.6219427000e-07
		////////////////////////////////
		,1.5403659240e-17
		,7.7040770440e-09
		,1.3144778400e-08
		,1.7016621990e-08
		,1.9798530900e-08
		,2.1821522970e-08
		,2.3322198710e-08
		,2.4462343830e-08
		,2.5352548970e-08
		,2.6068754050e-08
		,2.6663069350e-08
		,2.7171182350e-08
		,2.7617466620e-08
		,2.8018515430e-08
		,2.8385592830e-08
		,2.8726342150e-08
		,2.9045982370e-08
		,2.9348151170e-08
		,2.9635497240e-08
		,2.9910089120e-08
		,3.0173681170e-08
		,3.0427867160e-08
		,3.0674146990e-08
		,3.0913935310e-08
		,3.1148540220e-08
		,3.1379135410e-08
		,3.1606740700e-08
		,3.1832215940e-08
		,3.2056268240e-08
		,3.2279467560e-08
		,3.2502266910e-08
		,3.2725023040e-08
		,3.2948016000e-08
		,3.3171463920e-08
		,3.3395536490e-08
		,3.3620365390e-08
		,3.3846053630e-08
		,3.4072682340e-08
		,3.4300316040e-08
		,3.4529006640e-08
		,3.4758796890e-08
		,3.4989720970e-08
		,3.5221806660e-08
		,3.5455076860e-08
		,3.5689550570e-08
		,3.5925243560e-08
		,3.6162169050e-08
		,3.6400337580e-08
		,3.6639759380e-08
		,3.6880444000e-08
		,3.7122399100e-08
		,3.7365630620e-08
		,3.7610141330e-08
		,3.7855934690e-08
		,3.8103017260e-08
		,3.8351393120e-08
		,3.8601065020e-08
		,3.8852035020e-08
		,3.9104304850e-08
		,3.9357875970e-08
		,3.9612749340e-08
		,3.9868925510e-08
		,4.0126404580e-08
		,4.0385187110e-08
		,4.0645273860e-08
		,4.0906664880e-08
		,4.1169359650e-08
		,4.1433357980e-08
		,4.1698660870e-08
		,4.1965269150e-08
		,4.2233183530e-08
		,4.2502404920e-08
		,4.2772934720e-08
		,4.3044774470e-08
		,4.3317926320e-08
		,4.3592392940e-08
		,4.3868177800e-08
		,4.4145285070e-08
		,4.4423720180e-08
		,4.4703489500e-08
		,4.4984600650e-08
		,4.5267062750e-08
		,4.5550886350e-08
		,4.5836084300e-08
		,4.6122671600e-08
		,4.6410666380e-08
		,4.6700090130e-08
		,4.6990969110e-08
		,4.7283334910e-08
		,4.7577216200e-08
		,4.7872629200e-08
		,4.8169649200e-08
		,4.8468342470e-08
		,4.8768791680e-08
		,4.9071103490e-08
		,4.9375415230e-08
		,4.9681906080e-08
		,4.9990811350e-08
		,5.0302442570e-08
		,5.0617213920e-08
		,5.0935272370e-08
		,5.1257192200e-08
		,5.1583899420e-08
		,5.1916409000e-08
		,5.2256058410e-08
		,5.2604608370e-08
		,5.2964382370e-08
		,5.3338450180e-08
		,5.3730871070e-08
		,5.4147016750e-08
		,5.4593999680e-08
		,5.5081233520e-08
		,5.5621185400e-08
		,5.6230417570e-08
		,5.6930873050e-08
		,5.7751654110e-08
		,5.8731363040e-08
		,5.9921205990e-08
		,6.1389113480e-08
		,6.3225197570e-08
		,6.5548983410e-08
		////////////////////////////////
		,6.9968237520e-18
		,1.8615866580e-14
		,3.1801074250e-14
		,4.1221325040e-14
		,4.8022298300e-14
		,5.3014600950e-14
		,5.6758514640e-14
		,5.9612087020e-14
		,6.1881149350e-14
		,6.3739268860e-14
		,6.5304036810e-14
		,6.6665421990e-14
		,6.7900913510e-14
		,6.8979077110e-14
		,7.0025179850e-14
		,7.1028726260e-14
		,7.1969351940e-14
		,7.2890083180e-14
		,7.3766534940e-14
		,7.4617505120e-14
		,7.5435109030e-14
		,7.6242374100e-14
		,7.7062954350e-14
		,7.7842231450e-14
		,7.8554514940e-14
		,7.9327108340e-14
		,8.0020489510e-14
		,8.0712147540e-14
		,8.1448868300e-14
		,8.2132432790e-14
		,8.2787017200e-14
		,8.3456117760e-14
		,8.4112790820e-14
		,8.4804448850e-14
		,8.5463367220e-14
		,8.6159620290e-14
		,8.6795093510e-14
		,8.7476569350e-14
		,8.8152040300e-14
		,8.8825318170e-14
		,8.9514991980e-14
		,9.0204718000e-14
		,9.0859772360e-14
		,9.1596754200e-14
		,9.2286532440e-14
		,9.2998189340e-14
		,9.3728330830e-14
		,9.4420093290e-14
		,9.5141044710e-14
		,9.5875415730e-14
		,9.6591719880e-14
		,9.7312775730e-14
		,9.8053517150e-14
		,9.8795929490e-14
		,9.9571290360e-14
		,1.0030273730e-13
		,1.0106927360e-13
		,1.0183210250e-13
		,1.0262161400e-13
		,1.0340731370e-13
		,1.0425431550e-13
		,1.0505865640e-13
		,1.0589479710e-13
		,1.0678670490e-13
		,1.0760749410e-13
		,1.0850989740e-13
		,1.0942196070e-13
		,1.1043506270e-13
		,1.1146529160e-13
		,1.1254491730e-13
		,1.1374150760e-13
		,1.1504623810e-13
		,1.1655409020e-13
		,1.1812146890e-13
		,1.2008725860e-13
		,1.2237162030e-13
		,1.2511971560e-13
		,1.2847592280e-13
		,1.3260540210e-13
		,1.3784030200e-13
		,1.4453167310e-13
		,1.5309938730e-13
		,1.6430428910e-13
		,1.7897588800e-13
		,1.9784526520e-13
		,2.1960293870e-13
		,2.4703940340e-13
		,2.8247447610e-13
		,3.2847015280e-13
		,3.8834447060e-13
		,4.6667184450e-13
		,5.6946363180e-13
		,7.0503210420e-13
		,8.8453809300e-13
		,1.1229543290e-12
		,1.4376843180e-12
		,1.8233392810e-12
		,2.3251135270e-12
		,2.9786506320e-12
		,3.8304998680e-12
		,4.9417682770e-12
		,6.3897256440e-12
		,8.2752953500e-12
		,1.0738402900e-11
		,1.3959651470e-11
		,1.8175471020e-11
		,2.3696522270e-11
		,3.0931684720e-11
		,4.0419359100e-11
		,5.2868313880e-11
		,6.9212477550e-11
		,9.0682937980e-11
		,1.1890324720e-10
		,1.5601521960e-10
		,2.0484587590e-10
		,2.6909793180e-10
		,3.5369406570e-10
		,4.6515438460e-10
		,6.1208027520e-10
		,8.0584630820e-10
		,1.0615014110e-09
		////////////////////////////////
		,1.0495320510e-17
		,7.9877151570e-09
		,1.3642139250e-08
		,1.7683269630e-08
		,2.0609720630e-08
		,2.2766470500e-08
		,2.4392088950e-08
		,2.5651490070e-08
		,2.6658623260e-08
		,2.7492182660e-08
		,2.8206478450e-08
		,2.8838955890e-08
		,2.9415395070e-08
		,2.9953504490e-08
		,3.0465404390e-08
		,3.0959341460e-08
		,3.1440873880e-08
		,3.1913688830e-08
		,3.2380167340e-08
		,3.2841774790e-08
		,3.3299331470e-08
		,3.3753199750e-08
		,3.4203415050e-08
		,3.4649777250e-08
		,3.5091916710e-08
		,3.5529341520e-08
		,3.5961470520e-08
		,3.6387659690e-08
		,3.6807225240e-08
		,3.7219467790e-08
		,3.7623697420e-08
		,3.8019264180e-08
		,3.8405594380e-08
		,3.8782232830e-08
		,3.9148890200e-08
		,3.9505491130e-08
		,3.9852213630e-08
		,4.0189511760e-08
		,4.0518106910e-08
		,4.0838947340e-08
		,4.1153136120e-08
		,4.1461845500e-08
		,4.1766232570e-08
		,4.2067373060e-08
		,4.2366219190e-08
		,4.2663581980e-08
		,4.2960131220e-08
		,4.3256407690e-08
		,4.3552840050e-08
		,4.3849762460e-08
		,4.4147434880e-08
		,4.4446066030e-08
		,4.4745818200e-08
		,4.5046814760e-08
		,4.5349150900e-08
		,4.5652900430e-08
		,4.5958121320e-08
		,4.6264859520e-08
		,4.6573152680e-08
		,4.6883030950e-08
		,4.7194518110e-08
		,4.7507632760e-08
		,4.7822391100e-08
		,4.8138807120e-08
		,4.8456892690e-08
		,4.8776657930e-08
		,4.9098110220e-08
		,4.9421253010e-08
		,4.9746085860e-08
		,5.0072617530e-08
		,5.0400854850e-08
		,5.0730800790e-08
		,5.1062457710e-08
		,5.1395826640e-08
		,5.1730908620e-08
		,5.2067705220e-08
		,5.2406218040e-08
		,5.2746447800e-08
		,5.3088394050e-08
		,5.3432056430e-08
		,5.3777436020e-08
		,5.4124534200e-08
		,5.4473352180e-08
		,5.4823891200e-08
		,5.5176153020e-08
		,5.5530139660e-08
		,5.5885853890e-08
		,5.6243299030e-08
		,5.6602479130e-08
		,5.6963398760e-08
		,5.7326063800e-08
		,5.7690482020e-08
		,5.8056661770e-08
		,5.8424612590e-08
		,5.8794345350e-08
		,5.9165872450e-08
		,5.9539207670e-08
		,5.9914366450e-08
		,6.0291366370e-08
		,6.0670226700e-08
		,6.1050969220e-08
		,6.1433617790e-08
		,6.1818189570e-08
		,6.2204716310e-08
		,6.2593232390e-08
		,6.2983774100e-08
		,6.3376382380e-08
		,6.3771104190e-08
		,6.4167994430e-08
		,6.4567118010e-08
		,6.4968553500e-08
		,6.5372397090e-08
		,6.5778768820e-08
		,6.6187678110e-08
		,6.6599343580e-08
		,6.7013969260e-08
		,6.7431805470e-08
		,6.7853169050e-08
		,6.8278468010e-08
		,6.8708229880e-08
		,6.9143139960e-08
		////////////////////////////////
		,1.1644080640e-17
		,8.0809518360e-09
		,1.3809432050e-08
		,1.7910941620e-08
		,2.0888027870e-08
		,2.3088606440e-08
		,2.4753440160e-08
		,2.6049081110e-08
		,2.7090706880e-08
		,2.7957940540e-08
		,2.8705805210e-08
		,2.9372306100e-08
		,2.9983676560e-08
		,3.0558006940e-08
		,3.1107753160e-08
		,3.1641470610e-08
		,3.2165012330e-08
		,3.2682355490e-08
		,3.3196172090e-08
		,3.3708222120e-08
		,3.4219623940e-08
		,3.4731040520e-08
		,3.5242807300e-08
		,3.5755020160e-08
		,3.6267595890e-08
		,3.6780314440e-08
		,3.7292848490e-08
		,3.7804785390e-08
		,3.8315642490e-08
		,3.8824879740e-08
		,3.9331908280e-08
		,3.9836097550e-08
		,4.0336780030e-08
		,4.0833254950e-08
		,4.1324790960e-08
		,4.1810630250e-08
		,4.2289997840e-08
		,4.2762117740e-08
		,4.3226225250e-08
		,4.3681588020e-08
		,4.4127534320e-08
		,4.4563489340e-08
		,4.4989016600e-08
		,4.5403865030e-08
		,4.5808015900e-08
		,4.6201721470e-08
		,4.6585523490e-08
		,4.6960241150e-08
		,4.7326923640e-08
		,4.7686773330e-08
		,4.8041054390e-08
		,4.8391004820e-08
		,4.8737768590e-08
		,4.9082352800e-08
		,4.9425609300e-08
		,4.9768233590e-08
		,5.0110787820e-08
		,5.0453731700e-08
		,5.0797423080e-08
		,5.1142135560e-08
		,5.1488079420e-08
		,5.1835416590e-08
		,5.2184271810e-08
		,5.2534741690e-08
		,5.2886901210e-08
		,5.3240808830e-08
		,5.3596510350e-08
		,5.3954041850e-08
		,5.4313431640e-08
		,5.4674702660e-08
		,5.5037873330e-08
		,5.5402959150e-08
		,5.5769972230e-08
		,5.6138921410e-08
		,5.6509815970e-08
		,5.6882656610e-08
		,5.7257444220e-08
		,5.7634192560e-08
		,5.8012908730e-08
		,5.8393595940e-08
		,5.8776256540e-08
		,5.9160891920e-08
		,5.9547503470e-08
		,5.9936091960e-08
		,6.0326657490e-08
		,6.0719200250e-08
		,6.1113721800e-08
		,6.1510223230e-08
		,6.1908705780e-08
		,6.2309171630e-08
		,6.2711623280e-08
		,6.3116063330e-08
		,6.3522495060e-08
		,6.3930922400e-08
		,6.4341349990e-08
		,6.4753783690e-08
		,6.5168230130e-08
		,6.5584697320e-08
		,6.6003194370e-08
		,6.6423731860e-08
		,6.6846321890e-08
		,6.7270978100e-08
		,6.7697715810e-08
		,6.8126552020e-08
		,6.8557505850e-08
		,6.8990598560e-08
		,6.9425852900e-08
		,6.9863293340e-08
		,7.0302943080e-08
		,7.0744829330e-08
		,7.1188986030e-08
		,7.1635446970e-08
		,7.2084248610e-08
		,7.2535430470e-08
		,7.2989036490e-08
		,7.3445115350e-08
		,7.3903722260e-08
		,7.4364920770e-08
		,7.4828783890e-08
		,7.5295356610e-08
		,7.5764713050e-08
		////////////////////////////////
		,2.0573079820e-17
		,8.1593065900e-09
		,1.3949725340e-08
		,1.8101348210e-08
		,2.1120120940e-08
		,2.3356480670e-08
		,2.5053056970e-08
		,2.6377782150e-08
		,2.7446854680e-08
		,2.8340655310e-08
		,2.9114773230e-08
		,2.9807641450e-08
		,3.0445822810e-08
		,3.1047668450e-08
		,3.1625848260e-08
		,3.2189102350e-08
		,3.2743451150e-08
		,3.3293032070e-08
		,3.3840677480e-08
		,3.4388313410e-08
		,3.4937234410e-08
		,3.5488292270e-08
		,3.6042026100e-08
		,3.6598750620e-08
		,3.7158616270e-08
		,3.7721650060e-08
		,3.8287782610e-08
		,3.8856865860e-08
		,3.9428685160e-08
		,4.0002966880e-08
		,4.0579383660e-08
		,4.1157558490e-08
		,4.1737067860e-08
		,4.2317445340e-08
		,4.2898184940e-08
		,4.3478744900e-08
		,4.4058550880e-08
		,4.4636999100e-08
		,4.5213457590e-08
		,4.5787266950e-08
		,4.6357739080e-08
		,4.6924155810e-08
		,4.7485768210e-08
		,4.8041798150e-08
		,4.8591442790e-08
		,4.9133884190e-08
		,4.9668302230e-08
		,5.0193891060e-08
		,5.0709884940e-08
		,5.1215602200e-08
		,5.1710475650e-08
		,5.2194087990e-08
		,5.2666221250e-08
		,5.3126906520e-08
		,5.3576462890e-08
		,5.4015514710e-08
		,5.4444976760e-08
		,5.4866001930e-08
		,5.5279899110e-08
		,5.5688034270e-08
		,5.6091735280e-08
		,5.6492216500e-08
		,5.6890559700e-08
		,5.7287700170e-08
		,5.7684399730e-08
		,5.8081264230e-08
		,5.8478770520e-08
		,5.8877290210e-08
		,5.9277110700e-08
		,5.9678453380e-08
		,6.0081488310e-08
		,6.0486346240e-08
		,6.0893127870e-08
		,6.1301910850e-08
		,6.1712755480e-08
		,6.2125708720e-08
		,6.2540807280e-08
		,6.2958080250e-08
		,6.3377550610e-08
		,6.3799236700e-08
		,6.4223152990e-08
		,6.4649310580e-08
		,6.5077714580e-08
		,6.5508356270e-08
		,6.5941242710e-08
		,6.6376393310e-08
		,6.6813818660e-08
		,6.7253523140e-08
		,6.7695508920e-08
		,6.8139777390e-08
		,6.8586329110e-08
		,6.9035165630e-08
		,6.9486289320e-08
		,6.9939702470e-08
		,7.0395407160e-08
		,7.0853405670e-08
		,7.1313700640e-08
		,7.1776295230e-08
		,7.2241193330e-08
		,7.2708399560e-08
		,7.3177919460e-08
		,7.3649759250e-08
		,7.4123927150e-08
		,7.4600432990e-08
		,7.5079287840e-08
		,7.5560504010e-08
		,7.6044095420e-08
		,7.6530077640e-08
		,7.7018468240e-08
		,7.7509286490e-08
		,7.8002553660e-08
		,7.8498292900e-08
		,7.8996529620e-08
		,7.9497290750e-08
		,8.0000604640e-08
		,8.0506500310e-08
		,8.1015013590e-08
		,8.1526180180e-08
		,8.2040037980e-08
		,8.2556627080e-08
		,8.3075989510e-08
		////////////////////////////////
		,-1.8799590460e-18
		,1.9583901420e-10
		,3.5951855790e-10
		,5.0112035110e-10
		,6.2827844580e-10
		,7.4666086550e-10
		,8.6032776630e-10
		,9.7207587040e-10
		,1.0838449690e-09
		,1.1971560170e-09
		,1.3135625430e-09
		,1.4348318150e-09
		,1.5626026590e-09
		,1.6978596140e-09
		,1.8406162510e-09
		,1.9899512970e-09
		,2.1444449100e-09
		,2.3029984420e-09
		,2.4656516450e-09
		,2.6336889920e-09
		,2.8090766250e-09
		,2.9939610620e-09
		,3.1904478360e-09
		,3.4003738500e-09
		,3.6253116280e-09
		,3.8666633720e-09
		,4.1257194720e-09
		,4.4037205670e-09
		,4.7019960570e-09
		,5.0221391960e-09
		,5.3660395450e-09
		,5.7358033000e-09
		,6.1337113950e-09
		,6.5622528820e-09
		,7.0241540640e-09
		,7.5223961240e-09
		,8.0602537960e-09
		,8.6413821280e-09
		,9.2699542840e-09
		,9.9508696420e-09
		,1.0690093960e-08
		,1.1494797940e-08
		,1.2373421380e-08
		,1.3336688070e-08
		,1.4397600620e-08
		,1.5572431860e-08
		,1.6882207040e-08
		,1.8352469470e-08
		,2.0020198610e-08
		,2.1937125410e-08
		,2.4172461450e-08
		,2.6814229030e-08
		,2.9973330550e-08
		,3.3801340200e-08
		,3.8550953650e-08
		,4.4542561450e-08
		,5.2173531820e-08
		,6.2027039760e-08
		,7.4912351850e-08
		,9.1835998420e-08
		,1.1427794150e-07
		,1.4411449000e-07
		,1.8392591380e-07
		,2.3708260030e-07
		,3.0796359020e-07
		,4.0229454750e-07
		,5.2730501280e-07
		,6.9139302600e-07
		,9.0081553340e-07
		,1.1702161070e-06
		,1.5133275920e-06
		,1.9415777810e-06
		,2.4639312270e-06
		,3.1013532340e-06
		,3.8698280160e-06
		,4.7877611200e-06
		,5.8724395830e-06
		,7.1409471940e-06
		,8.6099189180e-06
		,1.0295341550e-05
		,1.2212401540e-05
		,1.4375410140e-05
		,1.6797820100e-05
		,1.9492233910e-05
		,2.2470509140e-05
		,2.5743890890e-05
		,2.9323169870e-05
		,3.3218858230e-05
		,3.7441351440e-05
		,4.2001078550e-05
		,4.6908642790e-05
		,5.2057574790e-05
		,5.7536456050e-05
		,6.3356202220e-05
		,6.9522764460e-05
		,7.6042138770e-05
		,8.2920445700e-05
		,8.9923968620e-05
		,9.7097984340e-05
		,1.0455473270e-04
		,1.1225865050e-04
		,1.1964172060e-04
		,1.2733984470e-04
		,1.3532840610e-04
		,1.4322858580e-04
		,1.5149477430e-04
		,1.6012985430e-04
		,1.6913954640e-04
		,1.7853175930e-04
		,1.8831610300e-04
		,1.9850352340e-04
		,2.0907973230e-04
		,2.1992810670e-04
		,2.3083371710e-04
		,2.4178396170e-04
		,2.5308029180e-04
		,2.6472923580e-04
		,2.7665021140e-04
		,2.8858827960e-04
		,3.0021903090e-04
		,3.1201753720e-04
		////////////////////////////////
		,2.3495668810e-18
		,8.7380058800e-10
		,1.5785931200e-09
		,2.1664621750e-09
		,2.6760058850e-09
		,3.1356722600e-09
		,3.5662099020e-09
		,3.9827230890e-09
		,4.3963310980e-09
		,4.8153329190e-09
		,5.2463494050e-09
		,5.6947973400e-09
		,6.1652229090e-09
		,6.6619080850e-09
		,7.1892048530e-09
		,7.7517512440e-09
		,8.3543769280e-09
		,9.0017101730e-09
		,9.6979899840e-09
		,1.0447123630e-08
		,1.1252595840e-08
		,1.2117061070e-08
		,1.3042164160e-08
		,1.4029092250e-08
		,1.5079234260e-08
		,1.6194056520e-08
		,1.7374704820e-08
		,1.8622790440e-08
		,1.9941313380e-08
		,2.1333668900e-08
		,2.2803470260e-08
		,2.4354157680e-08
		,2.5987894940e-08
		,2.7704678580e-08
		,2.9501862760e-08
		,3.1373581450e-08
		,3.3310041200e-08
		,3.5298058800e-08
		,3.7324354920e-08
		,3.9380675200e-08
		,4.1466793990e-08
		,4.3588845880e-08
		,4.5755781170e-08
		,4.7977889670e-08
		,5.0267721010e-08
		,5.2640764100e-08
		,5.5113835840e-08
		,5.7703573720e-08
		,6.0425196120e-08
		,6.3295581210e-08
		,6.6333456080e-08
		,6.9560182560e-08
		,7.3001986510e-08
		,7.6691662850e-08
		,8.0673804600e-08
		,8.5008656440e-08
		,8.9776527900e-08
		,9.5080286790e-08
		,1.0101018170e-07
		,1.0777364460e-07
		,1.1560913970e-07
		,1.2479588830e-07
		,1.3581075860e-07
		,1.4925843680e-07
		,1.6595486510e-07
		,1.8693756190e-07
		,2.1357564460e-07
		,2.4787902600e-07
		,2.9237232510e-07
		,3.5020860870e-07
		,4.2589333330e-07
		,5.2487871470e-07
		,6.5435455310e-07
		,8.2319600150e-07
		,1.0424107380e-06
		,1.3252831680e-06
		,1.6874006800e-06
		,2.1467214580e-06
		,2.7231782330e-06
		,3.4382594410e-06
		,4.3144550750e-06
		,5.3745064300e-06
		,6.6407489760e-06
		,8.1345310840e-06
		,9.8757895580e-06
		,1.1882814100e-05
		,1.4157479890e-05
		,1.6705300510e-05
		,1.9549546940e-05
		,2.2699608320e-05
		,2.6163615060e-05
		,2.9948703320e-05
		,3.4061277710e-05
		,3.8443109700e-05
		,4.3108658380e-05
		,4.7914977130e-05
		,5.2847502280e-05
		,5.8061287660e-05
		,6.3559120460e-05
		,6.9344186240e-05
		,7.5420209020e-05
		,8.1791539440e-05
		,8.8463218880e-05
		,9.5441014730e-05
		,1.0273147320e-04
		,1.1034194700e-04
		,1.1828056220e-04
		,1.2655618280e-04
		,1.3517834250e-04
		,1.4415731210e-04
		,1.5350213690e-04
		,1.6320960510e-04
		,1.7326532150e-04
		,1.8340326450e-04
		,1.9388434170e-04
		,2.0469786690e-04
		,2.1555217380e-04
		,2.2617191850e-04
		,2.3710397060e-04
		,2.4836862190e-04
		,2.5999165510e-04
		////////////////////////////////
		,-2.1043366650e-17
		,4.3580334280e-09
		,7.9294614670e-09
		,1.0934855270e-08
		,1.3536156930e-08
		,1.5847423730e-08
		,1.7947387150e-08
		,1.9902318670e-08
		,2.1770031930e-08
		,2.3605529220e-08
		,2.5434634920e-08
		,2.7268183630e-08
		,2.9113061820e-08
		,3.0978005970e-08
		,3.2874630800e-08
		,3.4818008270e-08
		,3.6822675370e-08
		,3.8898661350e-08
		,4.1052212980e-08
		,4.3288859580e-08
		,4.5614580670e-08
		,4.8035629480e-08
		,5.0558673010e-08
		,5.3190712230e-08
		,5.5939074860e-08
		,5.8811815420e-08
		,6.1816965760e-08
		,6.4961233190e-08
		,6.8249288760e-08
		,7.1683149270e-08
		,7.5261856330e-08
		,7.8982473580e-08
		,8.2841980490e-08
		,8.6839564330e-08
		,9.0976670710e-08
		,9.5251270800e-08
		,9.9655796300e-08
		,1.0417797620e-07
		,1.0880427670e-07
		,1.1352479360e-07
		,1.1833386660e-07
		,1.2322600850e-07
		,1.2819312450e-07
		,1.3322573660e-07
		,1.3831620910e-07
		,1.4346022670e-07
		,1.4865567700e-07
		,1.5390133140e-07
		,1.5919660130e-07
		,1.6454143880e-07
		,1.6993574930e-07
		,1.7537889910e-07
		,1.8086967080e-07
		,1.8640649000e-07
		,1.9198673620e-07
		,1.9760892160e-07
		,2.0327397060e-07
		,2.0898335750e-07
		,2.1474096760e-07
		,2.2055494460e-07
		,2.2644081500e-07
		,2.3242624090e-07
		,2.3855731170e-07
		,2.4490668960e-07
		,2.5151284730e-07
		,2.5850320480e-07
		,2.6606236620e-07
		,2.7440882610e-07
		,2.8382127240e-07
		,2.9468305340e-07
		,3.0749583690e-07
		,3.2291586180e-07
		,3.4183150920e-07
		,3.6538825350e-07
		,3.9509266480e-07
		,4.3302145390e-07
		,4.8191592410e-07
		,5.4517139240e-07
		,6.2730682550e-07
		,7.3404373740e-07
		,8.7270147500e-07
		,1.0522373530e-06
		,1.2838470850e-06
		,1.5810028360e-06
		,1.9597229830e-06
		,2.4385743090e-06
		,3.0385462590e-06
		,3.7827437680e-06
		,4.6956618070e-06
		,5.8025119440e-06
		,7.1282061120e-06
		,8.6964230020e-06
		,1.0528801580e-05
		,1.2644269100e-05
		,1.5058671810e-05
		,1.7784678980e-05
		,2.0831929370e-05
		,2.4207362990e-05
		,2.7915666410e-05
		,3.1959776600e-05
		,3.6341382130e-05
		,4.1061382010e-05
		,4.6120289930e-05
		,5.1518590990e-05
		,5.7257006080e-05
		,6.3336701520e-05
		,6.9759438200e-05
		,7.6527664090e-05
		,8.3644556660e-05
		,9.1114023460e-05
		,9.8937417510e-05
		,1.0709394870e-04
		,1.1553007350e-04
		,1.2430876880e-04
		,1.3334434640e-04
		,1.4259282430e-04
		,1.5216366130e-04
		,1.6206011760e-04
		,1.7223737750e-04
		,1.8236743960e-04
		,1.9255126970e-04
		////////////////////////////////
		,-1.4359671360e-17
		,2.0229760540e-08
		,3.6132509490e-08
		,4.8795621510e-08
		,5.9058059130e-08
		,6.7580969050e-08
		,7.4880450510e-08
		,8.1381655450e-08
		,8.7384641130e-08
		,9.3091898120e-08
		,9.8626789330e-08
		,1.0402201840e-07
		,1.0926152260e-07
		,1.1434837060e-07
		,1.1927891210e-07
		,1.2406013150e-07
		,1.2876224930e-07
		,1.3346044940e-07
		,1.3819412770e-07
		,1.4298764950e-07
		,1.4785457570e-07
		,1.5279714850e-07
		,1.5780781400e-07
		,1.6287074380e-07
		,1.6795978910e-07
		,1.7303713750e-07
		,1.7806327660e-07
		,1.8301287770e-07
		,1.8787195830e-07
		,1.9262854630e-07
		,1.9727660250e-07
		,2.0182331980e-07
		,2.0628420300e-07
		,2.1067347710e-07
		,2.1500206460e-07
		,2.1927913100e-07
		,2.2351322110e-07
		,2.2771408820e-07
		,2.3189306000e-07
		,2.3606181530e-07
		,2.4023067560e-07
		,2.4440517290e-07
		,2.4858658880e-07
		,2.5277339660e-07
		,2.5696176330e-07
		,2.6114551250e-07
		,2.6531597160e-07
		,2.6946271720e-07
		,2.7357657920e-07
		,2.7765311900e-07
		,2.8169187830e-07
		,2.8569249790e-07
		,2.8965258060e-07
		,2.9356861300e-07
		,2.9743868720e-07
		,3.0126420840e-07
		,3.0504871280e-07
		,3.0879606230e-07
		,3.1251017450e-07
		,3.1619555810e-07
		,3.1985694580e-07
		,3.2349881060e-07
		,3.2712835440e-07
		,3.3075297420e-07
		,3.3438168880e-07
		,3.3802592230e-07
		,3.4170058780e-07
		,3.4542554700e-07
		,3.4922750630e-07
		,3.5314259770e-07
		,3.5720162310e-07
		,3.6143108970e-07
		,3.6592768470e-07
		,3.7078733890e-07
		,3.7613682450e-07
		,3.8214628080e-07
		,3.8904108790e-07
		,3.9712053200e-07
		,4.0678166670e-07
		,4.1855061810e-07
		,4.3312355220e-07
		,4.5142004340e-07
		,4.7465004570e-07
		,5.0438702690e-07
		,5.4272658190e-07
		,5.9224493010e-07
		,6.5651276070e-07
		,7.4004031140e-07
		,8.4851488890e-07
		,9.8921211330e-07
		,1.1711930180e-06
		,1.4055873540e-06
		,1.7059584920e-06
		,2.0884844610e-06
		,2.5720459760e-06
		,3.1779626760e-06
		,3.9304135750e-06
		,4.8552476580e-06
		,5.9793288190e-06
		,7.3305135340e-06
		,8.9357979620e-06
		,1.0820680920e-05
		,1.3008330510e-05
		,1.5518991600e-05
		,1.8367703750e-05
		,2.1564919870e-05
		,2.5122696650e-05
		,2.9047523570e-05
		,3.3343236450e-05
		,3.8011482770e-05
		,4.3052188030e-05
		,4.8463994390e-05
		,5.4244672320e-05
		,6.0391444630e-05
		,6.6901278120e-05
		,7.3770400680e-05
		,8.0991519180e-05
		,8.8565618500e-05
		,9.6490439390e-05
		,1.0476435310e-04
		,1.1338648620e-04
		////////////////////////////////
		,-8.2503561270e-18
		,5.0447401510e-08
		,8.8000549700e-08
		,1.1616754410e-07
		,1.3754906520e-07
		,1.5408547920e-07
		,1.6716929990e-07
		,1.7777635370e-07
		,1.8658950880e-07
		,1.9410258300e-07
		,2.0072838700e-07
		,2.0675760070e-07
		,2.1237134730e-07
		,2.1768355690e-07
		,2.2275957790e-07
		,2.2762168210e-07
		,2.3228634350e-07
		,2.3678802050e-07
		,2.4116627930e-07
		,2.4546000050e-07
		,2.4968501670e-07
		,2.5384972660e-07
		,2.5795906600e-07
		,2.6201218410e-07
		,2.6601947600e-07
		,2.6998912030e-07
		,2.7392161370e-07
		,2.7781464100e-07
		,2.8166450090e-07
		,2.8546383470e-07
		,2.8919889710e-07
		,2.9284941850e-07
		,2.9640598650e-07
		,2.9988587770e-07
		,3.0331328590e-07
		,3.0670388720e-07
		,3.1006602290e-07
		,3.1340342930e-07
		,3.1671648780e-07
		,3.2000379220e-07
		,3.2326289660e-07
		,3.2648978870e-07
		,3.2968157620e-07
		,3.3283798290e-07
		,3.3595895420e-07
		,3.3904535230e-07
		,3.4209996140e-07
		,3.4512596610e-07
		,3.4812660090e-07
		,3.5110489830e-07
		,3.5406335920e-07
		,3.5700396630e-07
		,3.5992823470e-07
		,3.6283725730e-07
		,3.6573164730e-07
		,3.6861143550e-07
		,3.7147597910e-07
		,3.7432385560e-07
		,3.7715284130e-07
		,3.7996030210e-07
		,3.8274413130e-07
		,3.8550366030e-07
		,3.8824005050e-07
		,3.9095619430e-07
		,3.9365602970e-07
		,3.9634373530e-07
		,3.9902340320e-07
		,4.0169791340e-07
		,4.0437104880e-07
		,4.0704545290e-07
		,4.0972383660e-07
		,4.1240982620e-07
		,4.1510897090e-07
		,4.1783023300e-07
		,4.2058670730e-07
		,4.2339578770e-07
		,4.2627964030e-07
		,4.2923875770e-07
		,4.3231776450e-07
		,4.3555604380e-07
		,4.3900454580e-07
		,4.4273037110e-07
		,4.4682226000e-07
		,4.5139786570e-07
		,4.5661335750e-07
		,4.6267611390e-07
		,4.6986141970e-07
		,4.7853445090e-07
		,4.8917876960e-07
		,5.0243440240e-07
		,5.1914661150e-07
		,5.4042921670e-07
		,5.6774646570e-07
		,6.0289548860e-07
		,6.4841441390e-07
		,7.0753584570e-07
		,7.8440146690e-07
		,8.8430534080e-07
		,1.0139547330e-06
		,1.1817724940e-06
		,1.3981854220e-06
		,1.6759151620e-06
		,2.0302301620e-06
		,2.4791293730e-06
		,3.0433211150e-06
		,3.7461156750e-06
		,4.6130009980e-06
		,5.6710808350e-06
		,6.9482413250e-06
		,8.4722465770e-06
		,1.0269769130e-05
		,1.2365522800e-05
		,1.4781553880e-05
		,1.7536789510e-05
		,2.0646829340e-05
		,2.4123986000e-05
		,2.7977517260e-05
		,3.2213994040e-05
		,3.6833172510e-05
		,4.1839208390e-05
		,4.7232714810e-05
		////////////////////////////////
		,-2.8198537020e-18
		,7.7120614150e-08
		,1.3251640020e-07
		,1.7247834870e-07
		,2.0154025870e-07
		,2.2292341360e-07
		,2.3889725700e-07
		,2.5107687260e-07
		,2.6061196690e-07
		,2.6829696180e-07
		,2.7468055860e-07
		,2.8014274930e-07
		,2.8494651630e-07
		,2.8927421000e-07
		,2.9325380640e-07
		,2.9697655290e-07
		,3.0050564370e-07
		,3.0388254890e-07
		,3.0713550050e-07
		,3.1028611950e-07
		,3.1335093210e-07
		,3.1634707980e-07
		,3.1928893260e-07
		,3.2218569070e-07
		,3.2504745120e-07
		,3.2788476450e-07
		,3.3070402510e-07
		,3.3350868340e-07
		,3.3630077010e-07
		,3.3908138060e-07
		,3.4185048160e-07
		,3.4460807940e-07
		,3.4735577830e-07
		,3.5009419890e-07
		,3.5282310240e-07
		,3.5554199340e-07
		,3.5824975580e-07
		,3.6094480260e-07
		,3.6362636250e-07
		,3.6629554550e-07
		,3.6895507930e-07
		,3.7160807640e-07
		,3.7425706220e-07
		,3.7690369980e-07
		,3.7954883950e-07
		,3.8219294300e-07
		,3.8483643690e-07
		,3.8747977510e-07
		,3.9012336130e-07
		,3.9276770400e-07
		,3.9541359020e-07
		,3.9806199400e-07
		,4.0071382500e-07
		,4.0336983750e-07
		,4.0603059960e-07
		,4.0869645310e-07
		,4.1136762050e-07
		,4.1404426550e-07
		,4.1672649170e-07
		,4.1941434620e-07
		,4.2210779940e-07
		,4.2480669210e-07
		,4.2751069300e-07
		,4.3021944760e-07
		,4.3293298480e-07
		,4.3565183940e-07
		,4.3837672610e-07
		,4.4110826390e-07
		,4.4384692110e-07
		,4.4659305180e-07
		,4.4934693210e-07
		,4.5210877750e-07
		,4.5487873910e-07
		,4.5765651110e-07
		,4.6044211890e-07
		,4.6323556160e-07
		,4.6603712550e-07
		,4.6884814910e-07
		,4.7167155950e-07
		,4.7451179430e-07
		,4.7737446060e-07
		,4.8026633630e-07
		,4.8319580000e-07
		,4.8616692480e-07
		,4.8919002380e-07
		,4.9228328520e-07
		,4.9546647100e-07
		,4.9876569680e-07
		,5.0221549240e-07
		,5.0586164720e-07
		,5.0976486940e-07
		,5.1400574970e-07
		,5.1869129020e-07
		,5.2396354880e-07
		,5.3001111090e-07
		,5.3708419890e-07
		,5.4551457640e-07
		,5.5574170820e-07
		,5.6834702480e-07
		,5.8409863140e-07
		,6.0400936150e-07
		,6.2931024000e-07
		,6.6177240000e-07
		,7.0367041850e-07
		,7.5793194310e-07
		,8.2833681830e-07
		,9.1973124560e-07
		,1.0382768690e-06
		,1.1917306560e-06
		,1.3897444150e-06
		,1.6441635560e-06
		,1.9692962830e-06
		,2.3821102400e-06
		,2.9023175180e-06
		,3.5522892080e-06
		,4.3567560950e-06
		,5.3423083580e-06
		,6.5366590310e-06
		,7.9677627110e-06
		,9.6628605260e-06
		,1.1647634770e-05
		////////////////////////////////
		,-1.3106478490e-17
		,9.2534369300e-08
		,1.5866608900e-07
		,2.0598512990e-07
		,2.3997714770e-07
		,2.6456834960e-07
		,2.8254384620e-07
		,2.9587682100e-07
		,3.0595883550e-07
		,3.1376737960e-07
		,3.1999762790e-07
		,3.2514005330e-07
		,3.2953012630e-07
		,3.3339684520e-07
		,3.3689755590e-07
		,3.4014104260e-07
		,3.4320268560e-07
		,3.4613510800e-07
		,3.4897500830e-07
		,3.5174757210e-07
		,3.5447239300e-07
		,3.5716481380e-07
		,3.5983498730e-07
		,3.6249003890e-07
		,3.6513502850e-07
		,3.6777331910e-07
		,3.7040707970e-07
		,3.7303761030e-07
		,3.7566538110e-07
		,3.7829019280e-07
		,3.8091186500e-07
		,3.8352963260e-07
		,3.8614235480e-07
		,3.8874985880e-07
		,3.9135412290e-07
		,3.9395841370e-07
		,3.9656553000e-07
		,3.9917738300e-07
		,4.0179498240e-07
		,4.0441923480e-07
		,4.0705109220e-07
		,4.0969108570e-07
		,4.1233955740e-07
		,4.1499676000e-07
		,4.1766289030e-07
		,4.2033810530e-07
		,4.2302252830e-07
		,4.2571626420e-07
		,4.2841943680e-07
		,4.3113217400e-07
		,4.3385457540e-07
		,4.3658672840e-07
		,4.3932871080e-07
		,4.4208059070e-07
		,4.4484242800e-07
		,4.4761427340e-07
		,4.5039615310e-07
		,4.5318809210e-07
		,4.5599017470e-07
		,4.5880248750e-07
		,4.6162509550e-07
		,4.6445805350e-07
		,4.6730141450e-07
		,4.7015523430e-07
		,4.7301957580e-07
		,4.7589451140e-07
		,4.7878012310e-07
		,4.8167649970e-07
		,4.8458373640e-07
		,4.8750193490e-07
		,4.9043120300e-07
		,4.9337165750e-07
		,4.9632342820e-07
		,4.9928666010e-07
		,5.0226151250e-07
		,5.0524816210e-07
		,5.0824681040e-07
		,5.1125768660e-07
		,5.1428105130e-07
		,5.1731707610e-07
		,5.2036602220e-07
		,5.2342830720e-07
		,5.2650424920e-07
		,5.2959407330e-07
		,5.3269780380e-07
		,5.3581531890e-07
		,5.3894715230e-07
		,5.4209592050e-07
		,5.4526643050e-07
		,5.4846353900e-07
		,5.5168977450e-07
		,5.5495409160e-07
		,5.5826459070e-07
		,5.6163168580e-07
		,5.6506898870e-07
		,5.6859443400e-07
		,5.7223174060e-07
		,5.7601233760e-07
		,5.7997791520e-07
		,5.8418380670e-07
		,5.8870345590e-07
		,5.9363437200e-07
		,5.9910601390e-07
		,6.0529017050e-07
		,6.1241471940e-07
		,6.2078171850e-07
		,6.3079128190e-07
		,6.4297283460e-07
		,6.5802608960e-07
		,6.7678862370e-07
		,7.0049011760e-07
		,7.3072218710e-07
		,7.6953603330e-07
		,8.1959865600e-07
		,8.8435921730e-07
		,9.6824970330e-07
		,1.0769209140e-06
		,1.2175111150e-06
		,1.3989389680e-06
		,1.6322044890e-06
		,1.9306719940e-06
		////////////////////////////////
		,-2.6108354490e-17
		,9.9804831070e-08
		,1.7138517920e-07
		,2.2289030760e-07
		,2.6016232590e-07
		,2.8734285900e-07
		,3.0737907020e-07
		,3.2241789290e-07
		,3.3395083150e-07
		,3.4300588870e-07
		,3.5029681990e-07
		,3.5632252150e-07
		,3.6143569390e-07
		,3.6588711730e-07
		,3.6985587440e-07
		,3.7347120650e-07
		,3.7682739990e-07
		,3.7999396490e-07
		,3.8302263180e-07
		,3.8595171920e-07
		,3.8880937570e-07
		,3.9161614610e-07
		,3.9438699170e-07
		,3.9713346300e-07
		,3.9986443040e-07
		,4.0258623560e-07
		,4.0530362350e-07
		,4.0802020850e-07
		,4.1073867820e-07
		,4.1346105060e-07
		,4.1618885160e-07
		,4.1892318880e-07
		,4.2166475460e-07
		,4.2441424440e-07
		,4.2717234940e-07
		,4.2993943480e-07
		,4.3271617450e-07
		,4.3550316570e-07
		,4.3830079810e-07
		,4.4110936310e-07
		,4.4392909250e-07
		,4.4676017840e-07
		,4.4960278560e-07
		,4.5245705530e-07
		,4.5532308560e-07
		,4.5820080610e-07
		,4.6108983870e-07
		,4.6399037180e-07
		,4.6690271740e-07
		,4.6982682320e-07
		,4.7276236160e-07
		,4.7570865740e-07
		,4.7866447620e-07
		,4.8162797720e-07
		,4.8459769230e-07
		,4.8757426330e-07
		,4.9056002700e-07
		,4.9355711910e-07
		,4.9656683580e-07
		,4.9958986710e-07
		,5.0262656740e-07
		,5.0567710620e-07
		,5.0874155140e-07
		,5.1181992640e-07
		,5.1491230560e-07
		,5.1801875200e-07
		,5.2113929030e-07
		,5.2427392270e-07
		,5.2742263900e-07
		,5.3058543170e-07
		,5.3376230330e-07
		,5.3695326880e-07
		,5.4015834560e-07
		,5.4337754580e-07
		,5.4661088790e-07
		,5.4985840690e-07
		,5.5312015450e-07
		,5.5639620070e-07
		,5.5968663530e-07
		,5.6299156040e-07
		,5.6631108940e-07
		,5.6964535830e-07
		,5.7299452530e-07
		,5.7635876840e-07
		,5.7973828330e-07
		,5.8313325750e-07
		,5.8654387550e-07
		,5.8997051860e-07
		,5.9341355580e-07
		,5.9687341630e-07
		,6.0035062160e-07
		,6.0384582420e-07
		,6.0735984820e-07
		,6.1089374710e-07
		,6.1444887580e-07
		,6.1802699330e-07
		,6.2162837990e-07
		,6.2525627800e-07
		,6.2891412420e-07
		,6.3260609620e-07
		,6.3633764830e-07
		,6.4011593540e-07
		,6.4395037110e-07
		,6.4785337080e-07
		,6.5184135650e-07
		,6.5593606550e-07
		,6.6016630040e-07
		,6.6457024660e-07
		,6.6919852900e-07
		,6.7411832420e-07
		,6.7941874760e-07
		,6.8521802780e-07
		,6.9167299130e-07
		,6.9899159650e-07
		,7.0744947850e-07
		,7.1741175720e-07
		,7.2936173150e-07
		,7.4386598260e-07
		,7.6177516910e-07
		,7.8419992850e-07
		,8.1256886860e-07
		////////////////////////////////
		,-4.2819120490e-18
		,1.0364676010e-07
		,1.7790255310e-07
		,2.3138120730e-07
		,2.7025253420e-07
		,2.9888289360e-07
		,3.2034400830e-07
		,3.3678704970e-07
		,3.4971292370e-07
		,3.6016544100e-07
		,3.6886829100e-07
		,3.7632161790e-07
		,3.8286983900e-07
		,3.8874916200e-07
		,3.9412092490e-07
		,3.9909522210e-07
		,4.0374768830e-07
		,4.0813111050e-07
		,4.1228355000e-07
		,4.1623417720e-07
		,4.2000727020e-07
		,4.2362462210e-07
		,4.2710656210e-07
		,4.3047176580e-07
		,4.3373639110e-07
		,4.3691527090e-07
		,4.4002633180e-07
		,4.4308850810e-07
		,4.4611674430e-07
		,4.4912202080e-07
		,4.5211274070e-07
		,4.5509557350e-07
		,4.5807567230e-07
		,4.6105692660e-07
		,4.6404222810e-07
		,4.6703374610e-07
		,4.7003346040e-07
		,4.7304308300e-07
		,4.7606388740e-07
		,4.7909672860e-07
		,4.8214202700e-07
		,4.8520006330e-07
		,4.8827148490e-07
		,4.9135682440e-07
		,4.9445637760e-07
		,4.9757023590e-07
		,5.0069853710e-07
		,5.0384172280e-07
		,5.0700010780e-07
		,5.1017386270e-07
		,5.1336310460e-07
		,5.1656791860e-07
		,5.1978832440e-07
		,5.2302404580e-07
		,5.2627473210e-07
		,5.2954091040e-07
		,5.3282283000e-07
		,5.3612052620e-07
		,5.3943399070e-07
		,5.4276317810e-07
		,5.4610798800e-07
		,5.4946842610e-07
		,5.5284458930e-07
		,5.5623649960e-07
		,5.5964414150e-07
		,5.6306748930e-07
		,5.6650651000e-07
		,5.6996114950e-07
		,5.7343130140e-07
		,5.7691686810e-07
		,5.8041791070e-07
		,5.8393449170e-07
		,5.8746661760e-07
		,5.9101428050e-07
		,5.9457746710e-07
		,5.9815617070e-07
		,6.0175041310e-07
		,6.0536022390e-07
		,6.0898564120e-07
		,6.1262670260e-07
		,6.1628343790e-07
		,6.1995588920e-07
		,6.2364412030e-07
		,6.2734821020e-07
		,6.3106824000e-07
		,6.3480429640e-07
		,6.3855648500e-07
		,6.4232493400e-07
		,6.4610979300e-07
		,6.4991123230e-07
		,6.5372942400e-07
		,6.5756453050e-07
		,6.6141668410e-07
		,6.6528617930e-07
		,6.6917330780e-07
		,6.7307839370e-07
		,6.7700180800e-07
		,6.8094397710e-07
		,6.8490537720e-07
		,6.8888655890e-07
		,6.9288819690e-07
		,6.9691112720e-07
		,7.0095592060e-07
		,7.0502341350e-07
		,7.0911535860e-07
		,7.1323354660e-07
		,7.1738026780e-07
		,7.2155847440e-07
		,7.2577199120e-07
		,7.3002581220e-07
		,7.3432649780e-07
		,7.3868268810e-07
		,7.4310578270e-07
		,7.4761084430e-07
		,7.5221779320e-07
		,7.5695299750e-07
		,7.6185135330e-07
		,7.6695914800e-07
		,7.7233774250e-07
		,7.7806853440e-07
		,7.8425950350e-07
		////////////////////////////////
		,6.7879582740e-18
		,1.8615605500e-14
		,3.1803371770e-14
		,4.1221325040e-14
		,4.8022298300e-14
		,5.3014183220e-14
		,5.6758619070e-14
		,5.9610207230e-14
		,6.1886370990e-14
		,6.3733942790e-14
		,6.5308527410e-14
		,6.6674507640e-14
		,6.7881019070e-14
		,6.8979494840e-14
		,7.0037450700e-14
		,7.1028778470e-14
		,7.1965749010e-14
		,7.2892171830e-14
		,7.3770451170e-14
		,7.4614215480e-14
		,7.5423621430e-14
		,7.6243261780e-14
		,7.7064990790e-14
		,7.7847244220e-14
		,7.8554410510e-14
		,7.9326481750e-14
		,8.0019027460e-14
		,8.0708857910e-14
		,8.1447928410e-14
		,8.2136975620e-14
		,8.2797669340e-14
		,8.3462853670e-14
		,8.4126053780e-14
		,8.4815309860e-14
		,8.5464620410e-14
		,8.6159829160e-14
		,8.6800628440e-14
		,8.7486803750e-14
		,8.8140134970e-14
		,8.8847457910e-14
		,8.9516454040e-14
		,9.0208529800e-14
		,9.0851417740e-14
		,9.1596754200e-14
		,9.2275149270e-14
		,9.2999285880e-14
		,9.3708279740e-14
		,9.4400773240e-14
		,9.5151801280e-14
		,9.5856826700e-14
		,9.6592137610e-14
		,9.7310791510e-14
		,9.8053621580e-14
		,9.8796033920e-14
		,9.9560742650e-14
		,1.0030158850e-13
		,1.0106796820e-13
		,1.0183612320e-13
		,1.0262171840e-13
		,1.0338820250e-13
		,1.0425243570e-13
		,1.0505896970e-13
		,1.0589672910e-13
		,1.0674018020e-13
		,1.0760352560e-13
		,1.0850979290e-13
		,1.0942415380e-13
		,1.1043433160e-13
		,1.1146993890e-13
		,1.1254925130e-13
		,1.1373602490e-13
		,1.1503370610e-13
		,1.1654223700e-13
		,1.1812376640e-13
		,1.2008798960e-13
		,1.2237073260e-13
		,1.2512018560e-13
		,1.2847754150e-13
		,1.3261114590e-13
		,1.3783873550e-13
		,1.4454206420e-13
		,1.5310909950e-13
		,1.6430282710e-13
		,1.7897223280e-13
		,1.9784589180e-13
		,2.1959427080e-13
		,2.4703021330e-13
		,2.8244732360e-13
		,3.2846117160e-13
		,3.8834379180e-13
		,4.6667403760e-13
		,5.6945861910e-13
		,7.0503685590e-13
		,8.8453798850e-13
		,1.1229653460e-12
		,1.4376993040e-12
		,1.8233485230e-12
		,2.3251474680e-12
		,2.9786514150e-12
		,3.8305013820e-12
		,4.9417671810e-12
		,6.3897471050e-12
		,8.2752956110e-12
		,1.0738413560e-11
		,1.3959650740e-11
		,1.8175476080e-11
		,2.3696496580e-11
		,3.0931675580e-11
		,4.0419344170e-11
		,5.2868302550e-11
		,6.9212476610e-11
		,9.0682936620e-11
		,1.1890323850e-10
		,1.5601522270e-10
		,2.0484584700e-10
		,2.6909793020e-10
		,3.5369405670e-10
		,4.6515436230e-10
		,6.1208025600e-10
		,8.0584630940e-10
		,1.0615014210e-09
		////////////////////////////////
		,1.2427326180e-17
		,1.0745270840e-07
		,1.8459541050e-07
		,2.4036856830e-07
		,2.8113963470e-07
		,3.1141320340e-07
		,3.3435976540e-07
		,3.5220211950e-07
		,3.6649393030e-07
		,3.7831844320e-07
		,3.8842880260e-07
		,3.9734386560e-07
		,4.0538853690e-07
		,4.1278234760e-07
		,4.1977977350e-07
		,4.2651776920e-07
		,4.3307767440e-07
		,4.3951256660e-07
		,4.4585684260e-07
		,4.5213196520e-07
		,4.5835028170e-07
		,4.6451760630e-07
		,4.7063501430e-07
		,4.7670028630e-07
		,4.8270887600e-07
		,4.8865439630e-07
		,4.9452907850e-07
		,5.0032418490e-07
		,5.0603035390e-07
		,5.1163791840e-07
		,5.1713724180e-07
		,5.2251910060e-07
		,5.2777514010e-07
		,5.3289840870e-07
		,5.3788395910e-07
		,5.4272946970e-07
		,5.4743580180e-07
		,5.5200736630e-07
		,5.5645216790e-07
		,5.6078144030e-07
		,5.6500888350e-07
		,5.6914963120e-07
		,5.7321915220e-07
		,5.7723228870e-07
		,5.8120256950e-07
		,5.8514183260e-07
		,5.8906010050e-07
		,5.9296563750e-07
		,5.9686512170e-07
		,6.0076386220e-07
		,6.0466599110e-07
		,6.0857453330e-07
		,6.1249157600e-07
		,6.1641943640e-07
		,6.2036029520e-07
		,6.2431549850e-07
		,6.2828604800e-07
		,6.3227285470e-07
		,6.3627663700e-07
		,6.4029786760e-07
		,6.4433674610e-07
		,6.4839355900e-07
		,6.5246874620e-07
		,6.5656277330e-07
		,6.6067594470e-07
		,6.6480844310e-07
		,6.6896039090e-07
		,6.7313183520e-07
		,6.7732249830e-07
		,6.8153137960e-07
		,6.8575889270e-07
		,6.9000571690e-07
		,6.9427181390e-07
		,6.9855718060e-07
		,7.0286197340e-07
		,7.0718622450e-07
		,7.1152988520e-07
		,7.1589287620e-07
		,7.2027509320e-07
		,7.2467638040e-07
		,7.2909644600e-07
		,7.3353491120e-07
		,7.3799169400e-07
		,7.4246681370e-07
		,7.4696017800e-07
		,7.5147162730e-07
		,7.5600094910e-07
		,7.6054784910e-07
		,7.6511208510e-07
		,7.6969354970e-07
		,7.7429203840e-07
		,7.7890727730e-07
		,7.8353896190e-07
		,7.8818674700e-07
		,7.9285022920e-07
		,7.9752896170e-07
		,8.0222247470e-07
		,8.0693025800e-07
		,8.1165175330e-07
		,8.1638635860e-07
		,8.2113343520e-07
		,8.2589229210e-07
		,8.3066212980e-07
		,8.3544207960e-07
		,8.4023125740e-07
		,8.4502885520e-07
		,8.4983415400e-07
		,8.5464645270e-07
		,8.5946511160e-07
		,8.6428960860e-07
		,8.6911958840e-07
		,8.7395488190e-07
		,8.7879548390e-07
		,8.8364160080e-07
		,8.8849369640e-07
		,8.9335232670e-07
		,8.9821847950e-07
		,9.0309337230e-07
		,9.0797836180e-07
		,9.1287498210e-07
		,9.1778496590e-07
		////////////////////////////////
		,-1.0861174600e-17
		,1.0870737580e-07
		,1.8679811440e-07
		,2.4331176670e-07
		,2.8468332590e-07
		,3.1546417760e-07
		,3.3885760370e-07
		,3.5710953030e-07
		,3.7178969130e-07
		,3.8399016430e-07
		,3.9444260700e-07
		,4.0361343190e-07
		,4.1196801730e-07
		,4.1979139860e-07
		,4.2726096240e-07
		,4.3449701460e-07
		,4.4158173940e-07
		,4.4857109240e-07
		,4.5550284750e-07
		,4.6240211350e-07
		,4.6928512340e-07
		,4.7616183390e-07
		,4.8303770710e-07
		,4.8991492520e-07
		,4.9679321790e-07
		,5.0367042600e-07
		,5.1054288580e-07
		,5.1740569660e-07
		,5.2425291250e-07
		,5.3107768640e-07
		,5.3787238480e-07
		,5.4462867800e-07
		,5.5133759640e-07
		,5.5798951670e-07
		,5.6457414340e-07
		,5.7108103430e-07
		,5.7750004170e-07
		,5.8382095070e-07
		,5.9003354620e-07
		,5.9612795740e-07
		,6.0209505260e-07
		,6.0792689840e-07
		,6.1361728880e-07
		,6.1916232360e-07
		,6.2456098030e-07
		,6.2981558880e-07
		,6.3493208900e-07
		,6.3991995550e-07
		,6.4479172100e-07
		,6.4956213360e-07
		,6.5424709490e-07
		,6.5886258330e-07
		,6.6342374680e-07
		,6.6794427030e-07
		,6.7243602920e-07
		,6.7690896580e-07
		,6.8137103710e-07
		,6.8582799320e-07
		,6.9028408110e-07
		,6.9474469880e-07
		,6.9921448730e-07
		,7.0369634280e-07
		,7.0819224910e-07
		,7.1270366950e-07
		,7.1723170610e-07
		,7.2177718320e-07
		,7.2634069410e-07
		,7.3092263500e-07
		,7.3552326580e-07
		,7.4014283520e-07
		,7.4478162910e-07
		,7.4943972540e-07
		,7.5411697760e-07
		,7.5881364020e-07
		,7.6352973490e-07
		,7.6826502480e-07
		,7.7301864630e-07
		,7.7778918230e-07
		,7.8257756420e-07
		,7.8738406460e-07
		,7.9220825410e-07
		,7.9704953370e-07
		,8.0190721730e-07
		,8.0678053930e-07
		,8.1166863940e-07
		,8.1657052410e-07
		,8.2148506940e-07
		,8.2641115800e-07
		,8.3134778090e-07
		,8.3629391770e-07
		,8.4124843730e-07
		,8.4621016520e-07
		,8.5117794640e-07
		,8.5615069390e-07
		,8.6112743430e-07
		,8.6610735230e-07
		,8.7108982990e-07
		,8.7607447730e-07
		,8.8106115210e-07
		,8.8604996090e-07
		,8.9104123510e-07
		,8.9603549820e-07
		,9.0103356590e-07
		,9.0603645690e-07
		,9.1104522580e-07
		,9.1606097370e-07
		,9.2108483860e-07
		,9.2611797690e-07
		,9.3116155070e-07
		,9.3621663110e-07
		,9.4128417420e-07
		,9.4636514360e-07
		,9.5146058940e-07
		,9.5657150940e-07
		,9.6169882360e-07
		,9.6684340160e-07
		,9.7200609080e-07
		,9.7718770960e-07
		,9.8238897770e-07
		,9.8761055200e-07
		,9.9285307440e-07
		////////////////////////////////
		,6.7357419100e-18
		,1.0973276050e-07
		,1.8859702160e-07
		,2.4571270380e-07
		,2.8756996580e-07
		,3.1875845970e-07
		,3.4250813020e-07
		,3.6108302660e-07
		,3.7606067850e-07
		,3.8848527200e-07
		,3.9910857520e-07
		,4.0857164620e-07
		,4.1725892950e-07
		,4.2542751310e-07
		,4.3325420310e-07
		,4.4086089820e-07
		,4.4833158100e-07
		,4.5572399040e-07
		,4.6307768070e-07
		,4.7041958910e-07
		,4.7776787940e-07
		,4.8513459260e-07
		,4.9252746950e-07
		,4.9995119850e-07
		,5.0740826600e-07
		,5.1489952810e-07
		,5.2242459200e-07
		,5.2998206390e-07
		,5.3756970530e-07
		,5.4518452890e-07
		,5.5282285250e-07
		,5.6048032970e-07
		,5.6815196610e-07
		,5.7583213220e-07
		,5.8351457910e-07
		,5.9119246070e-07
		,5.9885836470e-07
		,6.0650435180e-07
		,6.1412199900e-07
		,6.2170244290e-07
		,6.2923641590e-07
		,6.3671427370e-07
		,6.4412601480e-07
		,6.5146129300e-07
		,6.5870941230e-07
		,6.6585923070e-07
		,6.7289895320e-07
		,6.7981709550e-07
		,6.8660423230e-07
		,6.9325213900e-07
		,6.9975366500e-07
		,7.0610347760e-07
		,7.1229874280e-07
		,7.1833969410e-07
		,7.2423004330e-07
		,7.2997713770e-07
		,7.3559176310e-07
		,7.4108756120e-07
		,7.4648011760e-07
		,7.5178587320e-07
		,7.5702103590e-07
		,7.6220060470e-07
		,7.6733739530e-07
		,7.7244100760e-07
		,7.7752020770e-07
		,7.8258574020e-07
		,7.8764571200e-07
		,7.9270535440e-07
		,7.9776826570e-07
		,8.0283695440e-07
		,8.0791310960e-07
		,8.1299777540e-07
		,8.1809148000e-07
		,8.2319433670e-07
		,8.2830612650e-07
		,8.3342636910e-07
		,8.3855438770e-07
		,8.4368937110e-07
		,8.4883043370e-07
		,8.5397667390e-07
		,8.5912723180e-07
		,8.6428135570e-07
		,8.6943843130e-07
		,8.7459756880e-07
		,8.7975669360e-07
		,8.8491602380e-07
		,8.9007849000e-07
		,8.9524527750e-07
		,9.0041712950e-07
		,9.0559497240e-07
		,9.1077986870e-07
		,9.1597285010e-07
		,9.2117485180e-07
		,9.2638673420e-07
		,9.3160953680e-07
		,9.3684432160e-07
		,9.4209200510e-07
		,9.4735339050e-07
		,9.5262918050e-07
		,9.5791996530e-07
		,9.6322633690e-07
		,9.6854895800e-07
		,9.7388839640e-07
		,9.7924513080e-07
		,9.8461958920e-07
		,9.9001216490e-07
		,9.9542322540e-07
		,1.0008531180e-06
		,1.0063021750e-06
		,1.0117707190e-06
		,1.0172590660e-06
		,1.0227675260e-06
		,1.0282964120e-06
		,1.0338460340e-06
		,1.0394167020e-06
		,1.0450087190e-06
		,1.0506223930e-06
		,1.0562580350e-06
		,1.0619160470e-06
		,1.0675968230e-06
		,1.0733007660e-06
		////////////////////////////////
		,2.6630178690e-17
		,4.7055651620e-10
		,8.5710579440e-10
		,1.1856119050e-09
		,1.4760144070e-09
		,1.7435710140e-09
		,1.9998924420e-09
		,2.2537967960e-09
		,2.5119595980e-09
		,2.7794101520e-09
		,3.0599977730e-09
		,3.3568185420e-09
		,3.6726206500e-09
		,4.0104099350e-09
		,4.3739248180e-09
		,4.7672580920e-09
		,5.1942092460e-09
		,5.6580675110e-09
		,6.1618496750e-09
		,6.7087595820e-09
		,7.3024440290e-09
		,7.9468434410e-09
		,8.6455585990e-09
		,9.4011803850e-09
		,1.0215298190e-08
		,1.1088816520e-08
		,1.2023496920e-08
		,1.3023283960e-08
		,1.4093336600e-08
		,1.5238247080e-08
		,1.6461293220e-08
		,1.7764304360e-08
		,1.9146798910e-08
		,2.0604318430e-08
		,2.2127934650e-08
		,2.3707761040e-08
		,2.5339946110e-08
		,2.7030911610e-08
		,2.8795694810e-08
		,3.0654522250e-08
		,3.2628953630e-08
		,3.4739312480e-08
		,3.7003827260e-08
		,3.9439109730e-08
		,4.2061100820e-08
		,4.4887132710e-08
		,4.7937202980e-08
		,5.1236323200e-08
		,5.4814596190e-08
		,5.8707963880e-08
		,6.2958625890e-08
		,6.7616806100e-08
		,7.2744153110e-08
		,7.8416759750e-08
		,8.4726739560e-08
		,9.1820939160e-08
		,9.9885423010e-08
		,1.0916602020e-07
		,1.1998887110e-07
		,1.3279442690e-07
		,1.4800509760e-07
		,1.6649560940e-07
		,1.8933546370e-07
		,2.1796153080e-07
		,2.5401605230e-07
		,3.0004267780e-07
		,3.5933547630e-07
		,4.3585120370e-07
		,5.3480346910e-07
		,6.6290734530e-07
		,8.2806129740e-07
		,1.0393395780e-06
		,1.3061717370e-06
		,1.6422482920e-06
		,2.0627456060e-06
		,2.5847320660e-06
		,3.2270585320e-06
		,4.0103041220e-06
		,4.9561891130e-06
		,6.0880631690e-06
		,7.4290208440e-06
		,8.9455101250e-06
		,1.0641036280e-05
		,1.2543431430e-05
		,1.4596007430e-05
		,1.6881738060e-05
		,1.9425105590e-05
		,2.2238539480e-05
		,2.5332400760e-05
		,2.8715352450e-05
		,3.2394482340e-05
		,3.6375533340e-05
		,4.0663027170e-05
		,4.5260482510e-05
		,5.0170736490e-05
		,5.5396337590e-05
		,6.0940050970e-05
		,6.6805449800e-05
		,7.2997490160e-05
		,7.9523278050e-05
		,8.6283819780e-05
		,9.3278219020e-05
		,1.0058534190e-04
		,1.0821109580e-04
		,1.1616305840e-04
		,1.2445102830e-04
		,1.3308421290e-04
		,1.4162871110e-04
		,1.5031649820e-04
		,1.5931149110e-04
		,1.6862072650e-04
		,1.7800543790e-04
		,1.8709358060e-04
		,1.9652357510e-04
		,2.0629519120e-04
		,2.1634643050e-04
		,2.2643127360e-04
		,2.3633419330e-04
		,2.4665703950e-04
		,2.5740058320e-04
		,2.6857038160e-04
		////////////////////////////////
		,1.2427326190e-17
		,2.0275648830e-09
		,3.7376464580e-09
		,5.2200614260e-09
		,6.5568518040e-09
		,7.8128807510e-09
		,9.0363799300e-09
		,1.0261063600e-08
		,1.1506952220e-08
		,1.2781186310e-08
		,1.4082109710e-08
		,1.5408597110e-08
		,1.6767396710e-08
		,1.8169500530e-08
		,1.9623066190e-08
		,2.1132235960e-08
		,2.2700806300e-08
		,2.4338571240e-08
		,2.6064075670e-08
		,2.7900560910e-08
		,2.9870617480e-08
		,3.1993898350e-08
		,3.4286937940e-08
		,3.6763346770e-08
		,3.9434197550e-08
		,4.2309424090e-08
		,4.5399621990e-08
		,4.8715913860e-08
		,5.2268316130e-08
		,5.6067088170e-08
		,6.0126587370e-08
		,6.4461529860e-08
		,6.9085587900e-08
		,7.4015575600e-08
		,7.9274149130e-08
		,8.4888047450e-08
		,9.0884986970e-08
		,9.7292577550e-08
		,1.0413977890e-07
		,1.1145888440e-07
		,1.1928555320e-07
		,1.2765710070e-07
		,1.3661083710e-07
		,1.4618310070e-07
		,1.5640843310e-07
		,1.6731836930e-07
		,1.7894025760e-07
		,1.9129700690e-07
		,2.0440913530e-07
		,2.1830175920e-07
		,2.3301535590e-07
		,2.4861243400e-07
		,2.6517145500e-07
		,2.8277773080e-07
		,3.0151887240e-07
		,3.2148394810e-07
		,3.4276490440e-07
		,3.6545977070e-07
		,3.8967564600e-07
		,4.1553414130e-07
		,4.4315608690e-07
		,4.7271291480e-07
		,5.0438740070e-07
		,5.3840271170e-07
		,5.7507437680e-07
		,6.1483800700e-07
		,6.5840324380e-07
		,7.0677840410e-07
		,7.6154479130e-07
		,8.2470529730e-07
		,8.9880592460e-07
		,9.8669760370e-07
		,1.0928080580e-06
		,1.2224274120e-06
		,1.3830004030e-06
		,1.5837671860e-06
		,1.8352750220e-06
		,2.1500712530e-06
		,2.5437045570e-06
		,3.0327564420e-06
		,3.6344703440e-06
		,4.3688222710e-06
		,5.2554774540e-06
		,6.3132840810e-06
		,7.5617089030e-06
		,9.0189334140e-06
		,1.0701678440e-05
		,1.2624925620e-05
		,1.4800791450e-05
		,1.7241747240e-05
		,1.9958003410e-05
		,2.2957971580e-05
		,2.6248714370e-05
		,2.9836212970e-05
		,3.3725689860e-05
		,3.7921983180e-05
		,4.2429982380e-05
		,4.7255089610e-05
		,5.2331769960e-05
		,5.7708151310e-05
		,6.3394862290e-05
		,6.9396582220e-05
		,7.5706521440e-05
		,8.2287220110e-05
		,8.9172216130e-05
		,9.6116224880e-05
		,1.0333734760e-04
		,1.1083524170e-04
		,1.1815211470e-04
		,1.2561716410e-04
		,1.3313279280e-04
		,1.4096079100e-04
		,1.4910250250e-04
		,1.5756214470e-04
		,1.6634625890e-04
		,1.7546322710e-04
		,1.8492294450e-04
		,1.9473658420e-04
		,2.0491642300e-04
		,2.1547576560e-04
		,2.2619029280e-04
		////////////////////////////////
		,-6.0050522360e-18
		,9.4891540860e-09
		,1.7344042490e-08
		,2.4025444850e-08
		,2.9902992750e-08
		,3.5273977110e-08
		,4.0374940350e-08
		,4.5367010980e-08
		,5.0307097860e-08
		,5.5280639410e-08
		,6.0467849340e-08
		,6.5956697340e-08
		,7.1788199170e-08
		,7.8005148510e-08
		,8.4661434570e-08
		,9.1807893520e-08
		,9.9484201050e-08
		,1.0772844640e-07
		,1.1656957740e-07
		,1.2602198220e-07
		,1.3609594480e-07
		,1.4679791090e-07
		,1.5811964740e-07
		,1.7003327770e-07
		,1.8250925920e-07
		,1.9555348420e-07
		,2.0922843720e-07
		,2.2363585810e-07
		,2.3888471410e-07
		,2.5507423970e-07
		,2.7228878360e-07
		,2.9059025080e-07
		,3.1000515800e-07
		,3.3050172270e-07
		,3.5196984130e-07
		,3.7424777370e-07
		,3.9719443130e-07
		,4.2070606880e-07
		,4.4469622260e-07
		,4.6907239260e-07
		,4.9376037910e-07
		,5.1877939890e-07
		,5.4426440180e-07
		,5.7039546520e-07
		,5.9732227110e-07
		,6.2514006150e-07
		,6.5390807950e-07
		,6.8368558150e-07
		,7.1455223660e-07
		,7.4659598390e-07
		,7.7989262940e-07
		,8.1450185780e-07
		,8.5047726970e-07
		,8.8787516040e-07
		,9.2675293260e-07
		,9.6716293010e-07
		,1.0091503500e-06
		,1.0527613460e-06
		,1.0980453920e-06
		,1.1450490860e-06
		,1.1938170690e-06
		,1.2443941210e-06
		,1.2968281030e-06
		,1.3511746750e-06
		,1.4075009010e-06
		,1.4658915550e-06
		,1.5263989890e-06
		,1.5891655030e-06
		,1.6543713710e-06
		,1.7222450820e-06
		,1.7930976670e-06
		,1.8673576930e-06
		,1.9456225670e-06
		,2.0286887260e-06
		,2.1177176430e-06
		,2.2142530520e-06
		,2.3203430650e-06
		,2.4386744050e-06
		,2.5726661550e-06
		,2.7269367570e-06
		,2.9071217010e-06
		,3.1203341590e-06
		,3.3764998420e-06
		,3.6874095090e-06
		,4.0671542170e-06
		,4.5312991030e-06
		,5.0987225120e-06
		,5.7915885700e-06
		,6.6329682070e-06
		,7.6457348820e-06
		,8.8541001600e-06
		,1.0280566820e-05
		,1.1944928540e-05
		,1.3867233490e-05
		,1.6064731500e-05
		,1.8551184970e-05
		,2.1337317490e-05
		,2.4432616970e-05
		,2.7844270970e-05
		,3.1546530350e-05
		,3.5507095110e-05
		,3.9711692190e-05
		,4.4182753200e-05
		,4.8940079800e-05
		,5.3984308390e-05
		,5.9315935910e-05
		,6.4934269650e-05
		,7.0839123750e-05
		,7.7031039110e-05
		,8.3511405120e-05
		,9.0282423420e-05
		,9.7347467830e-05
		,1.0471078250e-04
		,1.1237766000e-04
		,1.2035437470e-04
		,1.2864818300e-04
		,1.3726721920e-04
		,1.4622061180e-04
		,1.5550881240e-04
		,1.6515055700e-04
		,1.7515748070e-04
		////////////////////////////////
		,-1.4725185940e-17
		,5.1799914620e-08
		,9.4513016940e-08
		,1.3061640470e-07
		,1.6203891690e-07
		,1.9029519910e-07
		,2.1654036570e-07
		,2.4153352420e-07
		,2.6579967620e-07
		,2.8979845070e-07
		,3.1392923050e-07
		,3.3845203100e-07
		,3.6345308990e-07
		,3.8877633250e-07
		,4.1423813740e-07
		,4.4003565340e-07
		,4.6621901230e-07
		,4.9301144430e-07
		,5.2081451670e-07
		,5.4984275360e-07
		,5.8034183790e-07
		,6.1253138530e-07
		,6.4655263570e-07
		,6.8245784960e-07
		,7.2024016340e-07
		,7.5989717270e-07
		,8.0143364490e-07
		,8.4481487650e-07
		,8.8992690440e-07
		,9.3658112930e-07
		,9.8459952470e-07
		,1.0338900400e-06
		,1.0844044210e-06
		,1.1360615700e-06
		,1.1887489060e-06
		,1.2423872700e-06
		,1.2969656380e-06
		,1.3525320710e-06
		,1.4091894950e-06
		,1.4670835340e-06
		,1.5263565280e-06
		,1.5871318970e-06
		,1.6495419740e-06
		,1.7136678720e-06
		,1.7795187080e-06
		,1.8470315650e-06
		,1.9160475110e-06
		,1.9862837340e-06
		,2.0573572420e-06
		,2.1289000890e-06
		,2.2006602840e-06
		,2.2724654910e-06
		,2.3441285590e-06
		,2.4153952130e-06
		,2.4859425490e-06
		,2.5554275720e-06
		,2.6235877150e-06
		,2.6903244510e-06
		,2.7556742250e-06
		,2.8197086480e-06
		,2.8824719330e-06
		,2.9439873360e-06
		,3.0042968450e-06
		,3.0634794710e-06
		,3.1216232090e-06
		,3.1787775860e-06
		,3.2349473360e-06
		,3.2901116240e-06
		,3.3442512850e-06
		,3.3973768530e-06
		,3.4495506560e-06
		,3.5008923840e-06
		,3.5515473870e-06
		,3.6017006250e-06
		,3.6516554290e-06
		,3.7017408330e-06
		,3.7523217600e-06
		,3.8037921150e-06
		,3.8565872950e-06
		,3.9112162720e-06
		,3.9683073730e-06
		,4.0286647960e-06
		,4.0933370980e-06
		,4.1637010190e-06
		,4.2415659500e-06
		,4.3293035070e-06
		,4.4298658960e-06
		,4.5473518310e-06
		,4.6867889010e-06
		,4.8548093800e-06
		,5.0596928050e-06
		,5.3117140510e-06
		,5.6234293710e-06
		,6.0099207560e-06
		,6.4887233940e-06
		,7.0800091190e-06
		,7.8069307350e-06
		,8.6943891890e-06
		,9.7685275900e-06
		,1.1055232120e-05
		,1.2581215170e-05
		,1.4371083450e-05
		,1.6446264020e-05
		,1.8826478430e-05
		,2.1527536780e-05
		,2.4561380690e-05
		,2.7937606430e-05
		,3.1662391160e-05
		,3.5739402090e-05
		,4.0170890920e-05
		,4.4957518980e-05
		,5.0099015360e-05
		,5.5594691130e-05
		,6.1443985910e-05
		,6.7646466610e-05
		,7.4202174740e-05
		,8.1111798370e-05
		,8.8376790870e-05
		,9.5999448520e-05
		,1.0398290960e-04
		,1.1233034150e-04
		////////////////////////////////
		,5.2199394680e-19
		,2.3504008660e-07
		,4.2756088740e-07
		,5.8801900130e-07
		,7.2508067840e-07
		,8.4436836000e-07
		,9.4827244150e-07
		,1.0387566660e-06
		,1.1209725550e-06
		,1.1992734090e-06
		,1.2758270930e-06
		,1.3514107160e-06
		,1.4255505520e-06
		,1.4973299210e-06
		,1.5675576900e-06
		,1.6367701650e-06
		,1.7046394280e-06
		,1.7708959270e-06
		,1.8355357540e-06
		,1.8983915450e-06
		,1.9597575900e-06
		,2.0208589000e-06
		,2.0824834510e-06
		,2.1449259890e-06
		,2.2079422930e-06
		,2.2715714390e-06
		,2.3353573540e-06
		,2.3983778050e-06
		,2.4599166070e-06
		,2.5197211890e-06
		,2.5780052300e-06
		,2.6352249810e-06
		,2.6917859180e-06
		,2.7479539280e-06
		,2.8038627930e-06
		,2.8595036720e-06
		,2.9147266840e-06
		,2.9694052970e-06
		,3.0235864030e-06
		,3.0773784540e-06
		,3.1308143700e-06
		,3.1838173950e-06
		,3.2362838310e-06
		,3.2882166530e-06
		,3.3396890430e-06
		,3.3907242400e-06
		,3.4412891100e-06
		,3.4913789490e-06
		,3.5410563860e-06
		,3.5903752760e-06
		,3.6393593050e-06
		,3.6880269150e-06
		,3.7363917400e-06
		,3.7844495670e-06
		,3.8321744160e-06
		,3.8795168540e-06
		,3.9264011760e-06
		,3.9727389210e-06
		,4.0184656640e-06
		,4.0635648410e-06
		,4.1080515730e-06
		,4.1519441370e-06
		,4.1952476800e-06
		,4.2379482790e-06
		,4.2800126950e-06
		,4.3213987980e-06
		,4.3620824640e-06
		,4.4020800210e-06
		,4.4414354840e-06
		,4.4801908200e-06
		,4.5183771990e-06
		,4.5560146830e-06
		,4.5931277450e-06
		,4.6297570370e-06
		,4.6659541390e-06
		,4.7017707840e-06
		,4.7372573350e-06
		,4.7724685170e-06
		,4.8074676110e-06
		,4.8422817200e-06
		,4.8770074260e-06
		,4.9117286450e-06
		,4.9465463860e-06
		,4.9815854220e-06
		,5.0170030960e-06
		,5.0530012530e-06
		,5.0898422480e-06
		,5.1278692740e-06
		,5.1675331370e-06
		,5.2094272140e-06
		,5.2543330020e-06
		,5.3032795050e-06
		,5.3576194770e-06
		,5.4191265830e-06
		,5.4899804820e-06
		,5.5732653910e-06
		,5.6728616660e-06
		,5.7937456320e-06
		,5.9422501570e-06
		,6.1263390430e-06
		,6.3559120140e-06
		,6.6431049130e-06
		,7.0025590720e-06
		,7.4515359380e-06
		,8.0101782550e-06
		,8.7012642280e-06
		,9.5498989060e-06
		,1.0582971660e-05
		,1.1828273390e-05
		,1.3313804370e-05
		,1.5066775200e-05
		,1.7112347840e-05
		,1.9472572170e-05
		,2.2167567750e-05
		,2.5212459730e-05
		,2.8620243340e-05
		,3.2400546080e-05
		,3.6559730050e-05
		,4.1101750100e-05
		,4.6028325560e-05
		,5.1339635400e-05
		////////////////////////////////
		,-1.0182361800e-17
		,5.4122910170e-07
		,9.7470755030e-07
		,1.3197218450e-06
		,1.5947536560e-06
		,1.8161946780e-06
		,1.9976611360e-06
		,2.1499159100e-06
		,2.2804902600e-06
		,2.3946741990e-06
		,2.4963003300e-06
		,2.5881887750e-06
		,2.6722853600e-06
		,2.7500953290e-06
		,2.8229405550e-06
		,2.8917269380e-06
		,2.9570536510e-06
		,3.0196501350e-06
		,3.0800738680e-06
		,3.1386787240e-06
		,3.1957602200e-06
		,3.2513327350e-06
		,3.3055377410e-06
		,3.3586871790e-06
		,3.4107910580e-06
		,3.4616459290e-06
		,3.5112562500e-06
		,3.5597804790e-06
		,3.6072203540e-06
		,3.6536658860e-06
		,3.6992481430e-06
		,3.7439361680e-06
		,3.7877125250e-06
		,3.8307478360e-06
		,3.8731176320e-06
		,3.9148765310e-06
		,3.9561088320e-06
		,3.9968651510e-06
		,4.0371843140e-06
		,4.0771153620e-06
		,4.1166823640e-06
		,4.1558918170e-06
		,4.1947479230e-06
		,4.2332452910e-06
		,4.2713589980e-06
		,4.3090292470e-06
		,4.3461549620e-06
		,4.3826629060e-06
		,4.4186069430e-06
		,4.4541079580e-06
		,4.4892538480e-06
		,4.5240886870e-06
		,4.5586298740e-06
		,4.5928824350e-06
		,4.6268508550e-06
		,4.6605310210e-06
		,4.6939093430e-06
		,4.7269669070e-06
		,4.7596848270e-06
		,4.7920577620e-06
		,4.8240874880e-06
		,4.8557770400e-06
		,4.8871364900e-06
		,4.9181773030e-06
		,4.9489076190e-06
		,4.9793323280e-06
		,5.0094533180e-06
		,5.0392758730e-06
		,5.0688177230e-06
		,5.0981126960e-06
		,5.1272051040e-06
		,5.1561389930e-06
		,5.1849501250e-06
		,5.2136633480e-06
		,5.2422930030e-06
		,5.2708439290e-06
		,5.2993151280e-06
		,5.3277018060e-06
		,5.3559982570e-06
		,5.3841995330e-06
		,5.4123010620e-06
		,5.4403020540e-06
		,5.4682120960e-06
		,5.4960536690e-06
		,5.5238590400e-06
		,5.5516552930e-06
		,5.5794775920e-06
		,5.6073715910e-06
		,5.6353845100e-06
		,5.6635742320e-06
		,5.6920119510e-06
		,5.7207855340e-06
		,5.7500054120e-06
		,5.7798130150e-06
		,5.8103914070e-06
		,5.8419794990e-06
		,5.8748910630e-06
		,5.9095393580e-06
		,5.9464693850e-06
		,5.9863998710e-06
		,6.0302778760e-06
		,6.0793485130e-06
		,6.1351237780e-06
		,6.1997891630e-06
		,6.2761138890e-06
		,6.3676616610e-06
		,6.4789954720e-06
		,6.6159446860e-06
		,6.7858902450e-06
		,6.9980353640e-06
		,7.2637219980e-06
		,7.5967165200e-06
		,8.0134440710e-06
		,8.5331048450e-06
		,9.1776446790e-06
		,9.9715239430e-06
		,1.0941260930e-05
		,1.2114746750e-05
		,1.3520385060e-05
		,1.5186185880e-05
		,1.7138765910e-05
		////////////////////////////////
		,-3.8119647210e-18
		,8.1146639730e-07
		,1.4565018810e-06
		,1.9644075330e-06
		,2.3621179930e-06
		,2.6731532790e-06
		,2.9169341050e-06
		,3.1085178440e-06
		,3.2589578450e-06
		,3.3784049710e-06
		,3.4761433420e-06
		,3.5584590910e-06
		,3.6295250570e-06
		,3.6923690060e-06
		,3.7492549030e-06
		,3.8017172960e-06
		,3.8507490730e-06
		,3.8969452840e-06
		,3.9406938800e-06
		,3.9825827870e-06
		,4.0230738590e-06
		,4.0624070530e-06
		,4.1007197850e-06
		,4.1380930560e-06
		,4.1745738220e-06
		,4.2101992130e-06
		,4.2450279080e-06
		,4.2791620130e-06
		,4.3127241650e-06
		,4.3458083780e-06
		,4.3784534510e-06
		,4.4106477790e-06
		,4.4424389790e-06
		,4.4739456260e-06
		,4.5052298170e-06
		,4.5363117850e-06
		,4.5671972870e-06
		,4.5978936040e-06
		,4.6284090130e-06
		,4.6587193820e-06
		,4.6888312510e-06
		,4.7187934530e-06
		,4.7486138630e-06
		,4.7782854000e-06
		,4.8077962890e-06
		,4.8371347130e-06
		,4.8662897930e-06
		,4.8952625750e-06
		,4.9240694400e-06
		,4.9527404010e-06
		,4.9813072540e-06
		,5.0097941620e-06
		,5.0382171470e-06
		,5.0665857860e-06
		,5.0949053820e-06
		,5.1231803520e-06
		,5.1514164700e-06
		,5.1796203510e-06
		,5.2077964650e-06
		,5.2359479820e-06
		,5.2640834030e-06
		,5.2922111100e-06
		,5.3203357000e-06
		,5.3484598750e-06
		,5.3765861000e-06
		,5.4047175210e-06
		,5.4328577820e-06
		,5.4610102170e-06
		,5.4891775210e-06
		,5.5173618380e-06
		,5.5455648140e-06
		,5.5737878210e-06
		,5.6020320920e-06
		,5.6302987650e-06
		,5.6585889430e-06
		,5.6869036860e-06
		,5.7152439490e-06
		,5.7436105040e-06
		,5.7720038590e-06
		,5.8004243560e-06
		,5.8288726240e-06
		,5.8573498330e-06
		,5.8858579140e-06
		,5.9143984920e-06
		,5.9429708100e-06
		,5.9715713700e-06
		,6.0001939250e-06
		,6.0288306640e-06
		,6.0574761830e-06
		,6.0861335280e-06
		,6.1148169610e-06
		,6.1435465550e-06
		,6.1723398440e-06
		,6.2012224510e-06
		,6.2302158730e-06
		,6.2593430310e-06
		,6.2886304290e-06
		,6.3181106240e-06
		,6.3478251140e-06
		,6.3778278530e-06
		,6.4081894870e-06
		,6.4390029510e-06
		,6.4703909550e-06
		,6.5025157350e-06
		,6.5355917030e-06
		,6.5699024670e-06
		,6.6058229950e-06
		,6.6438487910e-06
		,6.6846342190e-06
		,6.7290416550e-06
		,6.7781013720e-06
		,6.8333434430e-06
		,6.8967121620e-06
		,6.9707192500e-06
		,7.0586187670e-06
		,7.1646010210e-06
		,7.2940223690e-06
		,7.4536695060e-06
		,7.6520516940e-06
		,7.8997069360e-06
		,8.2094987420e-06
		////////////////////////////////
		,-3.4464501360e-18
		,9.3897573480e-07
		,1.6826783550e-06
		,2.2663595710e-06
		,2.7208802110e-06
		,3.0731087380e-06
		,3.3467748920e-06
		,3.5610073480e-06
		,3.7304700230e-06
		,3.8662835620e-06
		,3.9768024800e-06
		,4.0682385520e-06
		,4.1451465460e-06
		,4.2108554770e-06
		,4.2679649540e-06
		,4.3185134240e-06
		,4.3640275670e-06
		,4.4056936290e-06
		,4.4444391010e-06
		,4.4809743920e-06
		,4.5157907800e-06
		,4.5492416960e-06
		,4.5816933660e-06
		,4.6134223700e-06
		,4.6445874810e-06
		,4.6752909740e-06
		,4.7056117350e-06
		,4.7356073200e-06
		,4.7653184840e-06
		,4.7947717140e-06
		,4.8239825100e-06
		,4.8529677040e-06
		,4.8818045830e-06
		,4.9105577830e-06
		,4.9392521270e-06
		,4.9678937340e-06
		,4.9964664450e-06
		,5.0249409630e-06
		,5.0533400530e-06
		,5.0816933820e-06
		,5.1100049450e-06
		,5.1382680780e-06
		,5.1664733520e-06
		,5.1946097650e-06
		,5.2226672280e-06
		,5.2506420010e-06
		,5.2785500880e-06
		,5.3063901060e-06
		,5.3342072410e-06
		,5.3620480900e-06
		,5.3899262590e-06
		,5.4178469730e-06
		,5.4458131000e-06
		,5.4738268250e-06
		,5.5018897020e-06
		,5.5300027000e-06
		,5.5581664160e-06
		,5.5863811830e-06
		,5.6146469810e-06
		,5.6429632110e-06
		,5.6713309400e-06
		,5.6997526710e-06
		,5.7282294640e-06
		,5.7567607370e-06
		,5.7853428900e-06
		,5.8139708240e-06
		,5.8426475210e-06
		,5.8713784070e-06
		,5.9001662660e-06
		,5.9290118480e-06
		,5.9579141350e-06
		,5.9868720890e-06
		,6.0158853880e-06
		,6.0449543720e-06
		,6.0740797270e-06
		,6.1032612900e-06
		,6.1324983810e-06
		,6.1617911000e-06
		,6.1911405150e-06
		,6.2205487200e-06
		,6.2500186090e-06
		,6.2795527770e-06
		,6.3091527550e-06
		,6.3388195050e-06
		,6.3685538390e-06
		,6.3983556400e-06
		,6.4282239990e-06
		,6.4581582090e-06
		,6.4881590450e-06
		,6.5182288660e-06
		,6.5483690620e-06
		,6.5785805950e-06
		,6.6088648770e-06
		,6.6392238450e-06
		,6.6696599890e-06
		,6.7001764470e-06
		,6.7307771140e-06
		,6.7614670140e-06
		,6.7922488180e-06
		,6.8231287490e-06
		,6.8541092180e-06
		,6.8851888140e-06
		,6.9163627750e-06
		,6.9476264330e-06
		,6.9789875020e-06
		,7.0104763070e-06
		,7.0421382680e-06
		,7.0740243600e-06
		,7.1061916180e-06
		,7.1387086210e-06
		,7.1716621240e-06
		,7.2051647840e-06
		,7.2393646940e-06
		,7.2744574610e-06
		,7.3107018910e-06
		,7.3484405490e-06
		,7.3881266760e-06
		,7.4303587550e-06
		,7.4758348850e-06
		,7.5256282900e-06
		,7.5811013140e-06
		////////////////////////////////
		,5.5347654140e-18
		,1.0080812650e-06
		,1.7976741700e-06
		,2.4119385520e-06
		,2.8884284480e-06
		,3.2584630740e-06
		,3.5473408680e-06
		,3.7749287500e-06
		,3.9563245630e-06
		,4.1027109940e-06
		,4.2233243080e-06
		,4.3251317990e-06
		,4.4127340730e-06
		,4.4893355440e-06
		,4.5573157020e-06
		,4.6181776670e-06
		,4.6729973730e-06
		,4.7231768320e-06
		,4.7697463440e-06
		,4.8133785250e-06
		,4.8545650170e-06
		,4.8936842440e-06
		,4.9310452740e-06
		,4.9669119710e-06
		,5.0015137330e-06
		,5.0350486510e-06
		,5.0676828910e-06
		,5.0995517490e-06
		,5.1307714430e-06
		,5.1614629780e-06
		,5.1917433450e-06
		,5.2216982930e-06
		,5.2513841250e-06
		,5.2808357520e-06
		,5.3100944550e-06
		,5.3392408640e-06
		,5.3683346860e-06
		,5.3974121930e-06
		,5.4264977020e-06
		,5.4556060600e-06
		,5.4847459890e-06
		,5.5139149540e-06
		,5.5430801550e-06
		,5.5721912340e-06
		,5.6012505490e-06
		,5.6303087110e-06
		,5.6594127370e-06
		,5.6885799190e-06
		,5.7178158510e-06
		,5.7471228510e-06
		,5.7765024860e-06
		,5.8059561900e-06
		,5.8354847260e-06
		,5.8650843740e-06
		,5.8947253310e-06
		,5.9243664320e-06
		,5.9540561630e-06
		,5.9838167550e-06
		,6.0136419890e-06
		,6.0435256500e-06
		,6.0734784770e-06
		,6.1035059820e-06
		,6.1336079470e-06
		,6.1637828770e-06
		,6.1940289080e-06
		,6.2243437990e-06
		,6.2547247520e-06
		,6.2851675950e-06
		,6.3156637260e-06
		,6.3461967180e-06
		,6.3767402330e-06
		,6.4072705340e-06
		,6.4377967390e-06
		,6.4683462780e-06
		,6.4989423070e-06
		,6.5295992210e-06
		,6.5603245880e-06
		,6.5911219320e-06
		,6.6219930230e-06
		,6.6529388280e-06
		,6.6839602710e-06
		,6.7150578300e-06
		,6.7462307550e-06
		,6.7774781270e-06
		,6.8087998140e-06
		,6.8401965300e-06
		,6.8716694300e-06
		,6.9032181680e-06
		,6.9348412870e-06
		,6.9665379880e-06
		,6.9983082480e-06
		,7.0301525720e-06
		,7.0620718450e-06
		,7.0940665270e-06
		,7.1261363650e-06
		,7.1582835420e-06
		,7.1905117600e-06
		,7.2228246340e-06
		,7.2552252830e-06
		,7.2877160820e-06
		,7.3202983950e-06
		,7.3529730720e-06
		,7.3857415560e-06
		,7.4186060770e-06
		,7.4515675750e-06
		,7.4846269030e-06
		,7.5177866100e-06
		,7.5510500300e-06
		,7.5844218090e-06
		,7.6179081500e-06
		,7.6515168690e-06
		,7.6852570400e-06
		,7.7191400480e-06
		,7.7531816590e-06
		,7.7874033510e-06
		,7.8218331670e-06
		,7.8565065710e-06
		,7.8914684690e-06
		,7.9267771020e-06
		,7.9625088430e-06
		,7.9987640020e-06
		////////////////////////////////
		,-3.4464501440e-18
		,1.8615448850e-14
		,3.1804624970e-14
		,4.1220750660e-14
		,4.8031645030e-14
		,5.3018673830e-14
		,5.6757365880e-14
		,5.9613810160e-14
		,6.1886475420e-14
		,6.3739268860e-14
		,6.5302835830e-14
		,6.6665421990e-14
		,6.7900913510e-14
		,6.8979181540e-14
		,7.0026171960e-14
		,7.1027890800e-14
		,7.1946011220e-14
		,7.2890239830e-14
		,7.3770033440e-14
		,7.4616513000e-14
		,7.5424770190e-14
		,7.6231721960e-14
		,7.7070055770e-14
		,7.7836853160e-14
		,7.8554514940e-14
		,7.9326481750e-14
		,8.0017460960e-14
		,8.0708753480e-14
		,8.1447928410e-14
		,8.2135461340e-14
		,8.2796259500e-14
		,8.3463532490e-14
		,8.4125113890e-14
		,8.4810036000e-14
		,8.5474645960e-14
		,8.6151787840e-14
		,8.6797808760e-14
		,8.7474062960e-14
		,8.8141910320e-14
		,8.8826675790e-14
		,8.9515096410e-14
		,9.0204822430e-14
		,9.0862017660e-14
		,9.1599365010e-14
		,9.2273321690e-14
		,9.2996779490e-14
		,9.3711203860e-14
		,9.4400877670e-14
		,9.5135300910e-14
		,9.5850821820e-14
		,9.6593912970e-14
		,9.7312671300e-14
		,9.8063542690e-14
		,9.8795825060e-14
		,9.9560847080e-14
		,1.0030158850e-13
		,1.0107204100e-13
		,1.0182996160e-13
		,1.0262171840e-13
		,1.0338841140e-13
		,1.0425222680e-13
		,1.0505896970e-13
		,1.0589338730e-13
		,1.0674044120e-13
		,1.0761193240e-13
		,1.0850994960e-13
		,1.0942253510e-13
		,1.1043506270e-13
		,1.1146429950e-13
		,1.1255682260e-13
		,1.1377581380e-13
		,1.1503370610e-13
		,1.1652213370e-13
		,1.1811859700e-13
		,1.2008845960e-13
		,1.2237083710e-13
		,1.2512154320e-13
		,1.2847999560e-13
		,1.3260456670e-13
		,1.3785032760e-13
		,1.4453585040e-13
		,1.5310037940e-13
		,1.6431494130e-13
		,1.7897103180e-13
		,1.9784009580e-13
		,2.1960586280e-13
		,2.4703021330e-13
		,2.8244868120e-13
		,3.2846002280e-13
		,3.8834457500e-13
		,4.6667393320e-13
		,5.6945861910e-13
		,7.0503513280e-13
		,8.8453809300e-13
		,1.1229644590e-12
		,1.4376849970e-12
		,1.8233607940e-12
		,2.3251143630e-12
		,2.9786551740e-12
		,3.8305013820e-12
		,4.9417678070e-12
		,6.3897293520e-12
		,8.2752903890e-12
		,1.0738408700e-11
		,1.3959648540e-11
		,1.8175481090e-11
		,2.3696523470e-11
		,3.0931678500e-11
		,4.0419329710e-11
		,5.2868300930e-11
		,6.9212470770e-11
		,9.0682939440e-11
		,1.1890325280e-10
		,1.5601522160e-10
		,2.0484584490e-10
		,2.6909793450e-10
		,3.5369404670e-10
		,4.6515437290e-10
		,6.1208026630e-10
		,8.0584631040e-10
		,1.0615014170e-09
		////////////////////////////////
		,-1.8380331810e-17
		,1.0761645840e-06
		,1.9128258310e-06
		,2.5594308150e-06
		,3.0579026560e-06
		,3.4423036500e-06
		,3.7413167140e-06
		,3.9768862140e-06
		,4.1635600660e-06
		,4.3145254100e-06
		,4.4407065900e-06
		,4.5491016170e-06
		,4.6445952700e-06
		,4.7306871320e-06
		,4.8098968880e-06
		,4.8840349510e-06
		,4.9543942280e-06
		,5.0218903520e-06
		,5.0871647920e-06
		,5.1506592050e-06
		,5.2126674520e-06
		,5.2733793170e-06
		,5.3329229340e-06
		,5.3913772980e-06
		,5.4487757190e-06
		,5.5051125170e-06
		,5.5603294770e-06
		,5.6142167060e-06
		,5.6665777190e-06
		,5.7176805390e-06
		,5.7676318690e-06
		,5.8164182140e-06
		,5.8640129840e-06
		,5.9103986710e-06
		,5.9555735520e-06
		,5.9995549230e-06
		,6.0423807580e-06
		,6.0841090450e-06
		,6.1248145580e-06
		,6.1645842680e-06
		,6.2035124600e-06
		,6.2416959950e-06
		,6.2792301220e-06
		,6.3162051530e-06
		,6.3527041360e-06
		,6.3888014760e-06
		,6.4245623160e-06
		,6.4600425980e-06
		,6.4952899690e-06
		,6.5303451540e-06
		,6.5652421250e-06
		,6.6000064390e-06
		,6.6346514860e-06
		,6.6691711210e-06
		,6.7035555610e-06
		,6.7378551600e-06
		,6.7721292220e-06
		,6.8064050910e-06
		,6.8406908110e-06
		,6.8749749750e-06
		,6.9092551910e-06
		,6.9435662610e-06
		,6.9779340810e-06
		,7.0123698780e-06
		,7.0468792640e-06
		,7.0814660330e-06
		,7.1161331860e-06
		,7.1508825610e-06
		,7.1857109510e-06
		,7.2205862460e-06
		,7.2554120260e-06
		,7.2902187950e-06
		,7.3250880160e-06
		,7.3600449800e-06
		,7.3950938130e-06
		,7.4302337790e-06
		,7.4654632100e-06
		,7.5007803800e-06
		,7.5361836440e-06
		,7.5716712430e-06
		,7.6072405400e-06
		,7.6428853630e-06
		,7.6785888060e-06
		,7.7143271940e-06
		,7.7501039480e-06
		,7.7859286260e-06
		,7.8217997580e-06
		,7.8577302700e-06
		,7.8937303050e-06
		,7.9298021580e-06
		,7.9659465050e-06
		,8.0021627530e-06
		,8.0384486720e-06
		,8.0748020260e-06
		,8.1112209090e-06
		,8.1477044210e-06
		,8.1842525760e-06
		,8.2208659850e-06
		,8.2575463780e-06
		,8.2942939430e-06
		,8.3311055620e-06
		,8.3679785790e-06
		,8.4049133370e-06
		,8.4419099030e-06
		,8.4789672250e-06
		,8.5160826320e-06
		,8.5532531920e-06
		,8.5904827500e-06
		,8.6277796900e-06
		,8.6651475340e-06
		,8.7025863860e-06
		,8.7400962110e-06
		,8.7776772630e-06
		,8.8153306220e-06
		,8.8530580650e-06
		,8.8908603130e-06
		,8.9287360760e-06
		,8.9666838670e-06
		,9.0047037380e-06
		,9.0427963790e-06
		,9.0809634720e-06
		////////////////////////////////
		,-1.4098589510e-17
		,1.0976911170e-06
		,1.9484776120e-06
		,2.6038167280e-06
		,3.1069916080e-06
		,3.4948599860e-06
		,3.7951716090e-06
		,4.0294292810e-06
		,4.2165314840e-06
		,4.3698336780e-06
		,4.4987348640e-06
		,4.6099882900e-06
		,4.7084812210e-06
		,4.7977556850e-06
		,4.8803720510e-06
		,4.9581713030e-06
		,5.0324697020e-06
		,5.1042038880e-06
		,5.1740375810e-06
		,5.2424386140e-06
		,5.3097332700e-06
		,5.3761417290e-06
		,5.4417849130e-06
		,5.5065360680e-06
		,5.5700561290e-06
		,5.6329405780e-06
		,5.6954278830e-06
		,5.7575239660e-06
		,5.8191951450e-06
		,5.8803918080e-06
		,5.9410522070e-06
		,6.0010996910e-06
		,6.0604370780e-06
		,6.1189682570e-06
		,6.1766301400e-06
		,6.2333666990e-06
		,6.2891162680e-06
		,6.3438180840e-06
		,6.3974179270e-06
		,6.4498719910e-06
		,6.5011499650e-06
		,6.5512375360e-06
		,6.6001381600e-06
		,6.6478738540e-06
		,6.6944847880e-06
		,6.7400276070e-06
		,6.7845725830e-06
		,6.8281999190e-06
		,6.8709956310e-06
		,6.9130475800e-06
		,6.9544422180e-06
		,6.9952622450e-06
		,7.0355847710e-06
		,7.0754798280e-06
		,7.1150095050e-06
		,7.1542274770e-06
		,7.1931780090e-06
		,7.2318917230e-06
		,7.2703708570e-06
		,7.3085813080e-06
		,7.3465607500e-06
		,7.3844194430e-06
		,7.4222161050e-06
		,7.4599733540e-06
		,7.4977009620e-06
		,7.5354019470e-06
		,7.5730748350e-06
		,7.6107204720e-06
		,7.6483519780e-06
		,7.6859868610e-06
		,7.7236313640e-06
		,7.7612735690e-06
		,7.7989252870e-06
		,7.8366041140e-06
		,7.8743306040e-06
		,7.9121258430e-06
		,7.9499893460e-06
		,7.9878541650e-06
		,8.0256392670e-06
		,8.0634482900e-06
		,8.1013283720e-06
		,8.1392831920e-06
		,8.1773087250e-06
		,8.2153967220e-06
		,8.2535358560e-06
		,8.2917317060e-06
		,8.3299987890e-06
		,8.3683385180e-06
		,8.4067371210e-06
		,8.4451722090e-06
		,8.4836447910e-06
		,8.5221661030e-06
		,8.5607401680e-06
		,8.5993670470e-06
		,8.6380454650e-06
		,8.6767736730e-06
		,8.7155497360e-06
		,8.7543714910e-06
		,8.7932356530e-06
		,8.8321352520e-06
		,8.8710672450e-06
		,8.9100412610e-06
		,8.9490615340e-06
		,8.9881276850e-06
		,9.0272388310e-06
		,9.0663947400e-06
		,9.1055947240e-06
		,9.1448372320e-06
		,9.1841200220e-06
		,9.2234404500e-06
		,9.2627952600e-06
		,9.3021787850e-06
		,9.3415823350e-06
		,9.3810035450e-06
		,9.4204493390e-06
		,9.4599234510e-06
		,9.4994249360e-06
		,9.5389508070e-06
		,9.5784978440e-06
		,9.6180627420e-06
		,9.6576419140e-06
		////////////////////////////////
		,-1.0652309130e-17
		,1.1147258020e-06
		,1.9762821510e-06
		,2.6376464760e-06
		,3.1445091390e-06
		,3.5328723450e-06
		,3.8329665560e-06
		,4.0686775460e-06
		,4.2577895220e-06
		,4.4131807080e-06
		,4.5441814380e-06
		,4.6575745310e-06
		,4.7582946570e-06
		,4.8499237890e-06
		,4.9350480400e-06
		,5.0155232320e-06
		,5.0926748230e-06
		,5.1674463400e-06
		,5.2405068300e-06
		,5.3123242010e-06
		,5.3831901370e-06
		,5.4529711490e-06
		,5.5215122200e-06
		,5.5896943170e-06
		,5.6577481980e-06
		,5.7257224940e-06
		,5.7936309010e-06
		,5.8614708160e-06
		,5.9292288330e-06
		,5.9968833170e-06
		,6.0644058280e-06
		,6.1317619660e-06
		,6.1989118720e-06
		,6.2658105590e-06
		,6.3324081540e-06
		,6.3986501340e-06
		,6.4644776190e-06
		,6.5298277460e-06
		,6.5946341390e-06
		,6.6588274120e-06
		,6.7223355090e-06
		,6.7850832460e-06
		,6.8469889810e-06
		,6.9079529620e-06
		,6.9678455940e-06
		,7.0265731780e-06
		,7.0841254530e-06
		,7.1405001710e-06
		,7.1956883950e-06
		,7.2496878500e-06
		,7.3025097080e-06
		,7.3541809190e-06
		,7.4047442950e-06
		,7.4542570750e-06
		,7.5027882960e-06
		,7.5504153730e-06
		,7.5972203790e-06
		,7.6432864810e-06
		,7.6886948280e-06
		,7.7335219520e-06
		,7.7778373800e-06
		,7.8217003410e-06
		,7.8651520580e-06
		,7.9081940660e-06
		,7.9507690410e-06
		,7.9928991380e-06
		,8.0347468720e-06
		,8.0764213380e-06
		,8.1179699370e-06
		,8.1594173860e-06
		,8.2007802010e-06
		,8.2420712330e-06
		,8.2833012930e-06
		,8.3244798030e-06
		,8.3656150910e-06
		,8.4067144720e-06
		,8.4477841350e-06
		,8.4888287500e-06
		,8.5298507710e-06
		,8.5708504670e-06
		,8.6118294250e-06
		,8.6527958290e-06
		,8.6937497000e-06
		,8.7346729610e-06
		,8.7755682250e-06
		,8.8163161050e-06
		,8.8569274110e-06
		,8.8975463080e-06
		,8.9382109770e-06
		,8.9789269500e-06
		,9.0196919610e-06
		,9.0605019200e-06
		,9.1013519220e-06
		,9.1422347660e-06
		,9.1831365550e-06
		,9.2240415400e-06
		,9.2649505010e-06
		,9.3058640930e-06
		,9.3467768970e-06
		,9.3876925540e-06
		,9.4286142680e-06
		,9.4695400780e-06
		,9.5104659680e-06
		,9.5513871490e-06
		,9.5922984140e-06
		,9.6331942390e-06
		,9.6740688110e-06
		,9.7149160180e-06
		,9.7557294350e-06
		,9.7965022990e-06
		,9.8372274740e-06
		,9.8778973510e-06
		,9.9185034160e-06
		,9.9590356860e-06
		,9.9994882380e-06
		,1.0039859400e-05
		,1.0080141890e-05
		,1.0120322370e-05
		,1.0160381810e-05
		,1.0200304980e-05
		,1.0240086650e-05
		////////////////////////////////
		,9.6076422420e-18
		,9.5199297020e-10
		,1.7685735780e-09
		,2.4934205400e-09
		,3.1582023610e-09
		,3.7831794770e-09
		,4.3790266840e-09
		,4.9524481720e-09
		,5.5118590950e-09
		,6.0676810730e-09
		,6.6307194310e-09
		,7.2120969370e-09
		,7.8231922750e-09
		,8.4748058410e-09
		,9.1766179520e-09
		,9.9372964720e-09
		,1.0764904310e-08
		,1.1666988150e-08
		,1.2650451170e-08
		,1.3721317300e-08
		,1.4884500210e-08
		,1.6143928870e-08
		,1.7503301380e-08
		,1.8967823910e-08
		,2.0546029220e-08
		,2.2249350350e-08
		,2.4090448070e-08
		,2.6081470400e-08
		,2.8234273920e-08
		,3.0561822420e-08
		,3.3079515090e-08
		,3.5805487630e-08
		,3.8759468780e-08
		,4.1961499480e-08
		,4.5430995600e-08
		,4.9185247040e-08
		,5.3236890620e-08
		,5.7592630440e-08
		,6.2258413710e-08
		,6.7250312110e-08
		,7.2597781350e-08
		,7.8335487990e-08
		,8.4494702620e-08
		,9.1099593950e-08
		,9.8167103040e-08
		,1.0570738970e-07
		,1.1371954760e-07
		,1.2218208730e-07
		,1.3104968130e-07
		,1.4027271150e-07
		,1.4983831180e-07
		,1.5979292600e-07
		,1.7022698000e-07
		,1.8126481530e-07
		,1.9305876350e-07
		,2.0577034410e-07
		,2.1956883630e-07
		,2.3463323910e-07
		,2.5116995030e-07
		,2.6941718360e-07
		,2.8972356920e-07
		,3.1258031640e-07
		,3.3862006950e-07
		,3.6866498750e-07
		,4.0379269410e-07
		,4.4534024820e-07
		,4.9478960680e-07
		,5.5483415500e-07
		,6.2864904560e-07
		,7.2030049360e-07
		,8.3427594520e-07
		,9.7677616410e-07
		,1.1557926500e-06
		,1.3806807560e-06
		,1.6620661280e-06
		,2.0130468620e-06
		,2.4497150930e-06
		,2.9902304840e-06
		,3.6552040270e-06
		,4.4624364940e-06
		,5.4256610040e-06
		,6.5770736500e-06
		,7.9478931620e-06
		,9.5688563130e-06
		,1.1470958480e-05
		,1.3683569810e-05
		,1.6231669560e-05
		,1.9052982420e-05
		,2.2069751950e-05
		,2.5338077450e-05
		,2.8781661020e-05
		,3.2558722290e-05
		,3.6714286210e-05
		,4.1266838430e-05
		,4.6228044860e-05
		,5.1605483900e-05
		,5.7402957780e-05
		,6.3620331040e-05
		,7.0253482310e-05
		,7.7294165640e-05
		,8.4730182790e-05
		,9.2545746920e-05
		,1.0072207660e-04
		,1.0923820180e-04
		,1.1807197490e-04
		,1.2720175170e-04
		,1.3649058640e-04
		,1.4592180670e-04
		,1.5555542430e-04
		,1.6537411450e-04
		,1.7535976990e-04
		,1.8549429060e-04
		,1.9576332740e-04
		,2.0616676590e-04
		,2.1640754290e-04
		,2.2641170710e-04
		,2.3655366440e-04
		,2.4685565860e-04
		,2.5721381250e-04
		,2.6776087740e-04
		,2.7773050090e-04
		////////////////////////////////
		,1.1644080650e-17
		,3.7325129940e-09
		,6.8769280780e-09
		,9.5951605960e-09
		,1.2019679240e-08
		,1.4268385730e-08
		,1.6440709710e-08
		,1.8609654920e-08
		,2.0834352640e-08
		,2.3163275970e-08
		,2.5632428470e-08
		,2.8266033360e-08
		,3.1082102660e-08
		,3.4103880960e-08
		,3.7364251480e-08
		,4.0898226720e-08
		,4.4737488340e-08
		,4.8909965960e-08
		,5.3439181000e-08
		,5.8336291280e-08
		,6.3589216770e-08
		,6.9161660020e-08
		,7.5012406760e-08
		,8.1133447870e-08
		,8.7569586050e-08
		,9.4391258110e-08
		,1.0165812200e-07
		,1.0940120750e-07
		,1.1761322890e-07
		,1.2624663490e-07
		,1.3524440900e-07
		,1.4459890660e-07
		,1.5436863310e-07
		,1.6463300610e-07
		,1.7545864420e-07
		,1.8690187590e-07
		,1.9902699460e-07
		,2.1190964210e-07
		,2.2562294400e-07
		,2.4022482570e-07
		,2.5575652080e-07
		,2.7225497920e-07
		,2.8977387340e-07
		,3.0839358260e-07
		,3.2821188120e-07
		,3.4933271460e-07
		,3.7186470970e-07
		,3.9592430160e-07
		,4.2163742130e-07
		,4.4913891300e-07
		,4.7857140970e-07
		,5.1008499030e-07
		,5.4383961720e-07
		,5.8000841130e-07
		,6.1877621160e-07
		,6.6033915160e-07
		,7.0490439310e-07
		,7.5268861050e-07
		,8.0391526590e-07
		,8.5881160620e-07
		,9.1760817260e-07
		,9.8053374750e-07
		,1.0478463270e-06
		,1.1198383440e-06
		,1.1968839760e-06
		,1.2794857170e-06
		,1.3683959450e-06
		,1.4646697990e-06
		,1.5696644020e-06
		,1.6850830300e-06
		,1.8130811340e-06
		,1.9564511880e-06
		,2.1184668040e-06
		,2.3042831440e-06
		,2.5202331760e-06
		,2.7742897100e-06
		,3.0762018530e-06
		,3.4370947620e-06
		,3.8684400120e-06
		,4.3865443490e-06
		,4.9999125610e-06
		,5.7253578520e-06
		,6.5828153690e-06
		,7.5854872110e-06
		,8.7413141960e-06
		,1.0085305410e-05
		,1.1649982160e-05
		,1.3460183430e-05
		,1.5541414080e-05
		,1.7916238720e-05
		,2.0604563150e-05
		,2.3624185020e-05
		,2.6990286350e-05
		,3.0714568730e-05
		,3.4808726950e-05
		,3.9280062590e-05
		,4.4132724970e-05
		,4.9367572040e-05
		,5.4982127000e-05
		,6.0970638810e-05
		,6.7324269370e-05
		,7.4028486530e-05
		,8.1070911800e-05
		,8.8436418190e-05
		,9.6084847590e-05
		,1.0394123050e-04
		,1.1205374310e-04
		,1.2041097100e-04
		,1.2900096320e-04
		,1.3781287510e-04
		,1.4683824000e-04
		,1.5607280300e-04
		,1.6537061850e-04
		,1.7457710300e-04
		,1.8386680770e-04
		,1.9332203420e-04
		,2.0269986610e-04
		,2.1191300550e-04
		,2.2134778760e-04
		,2.3096041630e-04
		,2.4034271720e-04
		////////////////////////////////
		,-2.2505424990e-17
		,1.7168586840e-08
		,3.2019755700e-08
		,4.5191270220e-08
		,5.7137854250e-08
		,6.8198811360e-08
		,7.8716055530e-08
		,8.8983139960e-08
		,9.9171230890e-08
		,1.0919772600e-07
		,1.1893772430e-07
		,1.2877833930e-07
		,1.3898757860e-07
		,1.4976011760e-07
		,1.6129301890e-07
		,1.7375265750e-07
		,1.8725642050e-07
		,2.0186968880e-07
		,2.1761542730e-07
		,2.3451207370e-07
		,2.5263537250e-07
		,2.7211503860e-07
		,2.9306813690e-07
		,3.1556616200e-07
		,3.3964930030e-07
		,3.6538112150e-07
		,3.9289455360e-07
		,4.2237286740e-07
		,4.5399788820e-07
		,4.8791536940e-07
		,5.2422544000e-07
		,5.6300136730e-07
		,6.0434459850e-07
		,6.4843594190e-07
		,6.9551421710e-07
		,7.4581094000e-07
		,7.9950861240e-07
		,8.5677697330e-07
		,9.1776919570e-07
		,9.8257301440e-07
		,1.0512700580e-06
		,1.1240053010e-06
		,1.2010048150e-06
		,1.2825735940e-06
		,1.3690578520e-06
		,1.4607504290e-06
		,1.5577880670e-06
		,1.6600663980e-06
		,1.7671851060e-06
		,1.8784487500e-06
		,1.9928971950e-06
		,2.1093327370e-06
		,2.2264834550e-06
		,2.3434070870e-06
		,2.4598364450e-06
		,2.5761014940e-06
		,2.6927760220e-06
		,2.8104599460e-06
		,2.9298432580e-06
		,3.0518181460e-06
		,3.1773885470e-06
		,3.3075155370e-06
		,3.4430396180e-06
		,3.5846805900e-06
		,3.7330612870e-06
		,3.8887354440e-06
		,4.0522166770e-06
		,4.2239762680e-06
		,4.4045119430e-06
		,4.5943813680e-06
		,4.7941873580e-06
		,5.0046217460e-06
		,5.2265003780e-06
		,5.4608080440e-06
		,5.7087617040e-06
		,5.9719040950e-06
		,6.2522469720e-06
		,6.5523528380e-06
		,6.8757416270e-06
		,7.2270410550e-06
		,7.6122032240e-06
		,8.0386813130e-06
		,8.5157560700e-06
		,9.0549367360e-06
		,9.6700509510e-06
		,1.0376650100e-05
		,1.1196647930e-05
		,1.2153613610e-05
		,1.3273431680e-05
		,1.4583483150e-05
		,1.6109298760e-05
		,1.7878407700e-05
		,1.9917877530e-05
		,2.2250816080e-05
		,2.4896793810e-05
		,2.7869076160e-05
		,3.1179189220e-05
		,3.4834905850e-05
		,3.8835540030e-05
		,4.3169805970e-05
		,4.7841460770e-05
		,5.2836838380e-05
		,5.8144602680e-05
		,6.3765058920e-05
		,6.9691465760e-05
		,7.5915322310e-05
		,8.2426618870e-05
		,8.9216010050e-05
		,9.6277128650e-05
		,1.0354648260e-04
		,1.1094553150e-04
		,1.1835055490e-04
		,1.2585811470e-04
		,1.3357707640e-04
		,1.4151487070e-04
		,1.4965940620e-04
		,1.5799980930e-04
		,1.6653093150e-04
		,1.7525533010e-04
		,1.8417957300e-04
		,1.9331265020e-04
		////////////////////////////////
		,2.4854822130e-17
		,8.2747314610e-08
		,1.5341495940e-07
		,2.1528854530e-07
		,2.7079176990e-07
		,3.2218558040e-07
		,3.7133612150e-07
		,4.1951357750e-07
		,4.6792105960e-07
		,5.1769494280e-07
		,5.6967878370e-07
		,6.2444489140e-07
		,6.8239827740e-07
		,7.4389019850e-07
		,8.0883613520e-07
		,8.7623879930e-07
		,9.4531953980e-07
		,1.0158602060e-06
		,1.0888583060e-06
		,1.1655163260e-06
		,1.2462519310e-06
		,1.3311234860e-06
		,1.4201013100e-06
		,1.5131548270e-06
		,1.6100364540e-06
		,1.7104185640e-06
		,1.8141187130e-06
		,1.9210582210e-06
		,2.0311118010e-06
		,2.1442103580e-06
		,2.2606433790e-06
		,2.3809832280e-06
		,2.5056962820e-06
		,2.6349868050e-06
		,2.7689665960e-06
		,2.9079153500e-06
		,3.0523181190e-06
		,3.2027201900e-06
		,3.3596215360e-06
		,3.5234555280e-06
		,3.6946159530e-06
		,3.8734487170e-06
		,4.0602488690e-06
		,4.2554918690e-06
		,4.4596960750e-06
		,4.6732179310e-06
		,4.8962773350e-06
		,5.1289426830e-06
		,5.3711202790e-06
		,5.6226623440e-06
		,5.8835397100e-06
		,6.1538557570e-06
		,6.4337025230e-06
		,6.7230230000e-06
		,7.0215176980e-06
		,7.3285792080e-06
		,7.6433140500e-06
		,7.9647712270e-06
		,8.2922967540e-06
		,8.6256409480e-06
		,8.9647397130e-06
		,9.3094836020e-06
		,9.6596441890e-06
		,1.0014960810e-05
		,1.0375349100e-05
		,1.0740969310e-05
		,1.1112014930e-05
		,1.1488575360e-05
		,1.1870644590e-05
		,1.2258189080e-05
		,1.2651183340e-05
		,1.3049586340e-05
		,1.3453307340e-05
		,1.3862163940e-05
		,1.4275935740e-05
		,1.4694436540e-05
		,1.5117422960e-05
		,1.5544627400e-05
		,1.5975775100e-05
		,1.6410618510e-05
		,1.6848994780e-05
		,1.7290915130e-05
		,1.7736701220e-05
		,1.8187169550e-05
		,1.8643819970e-05
		,1.9109035850e-05
		,1.9586096850e-05
		,2.0079652030e-05
		,2.0595683840e-05
		,2.1141449540e-05
		,2.1725803560e-05
		,2.2359473300e-05
		,2.3055266750e-05
		,2.3828173840e-05
		,2.4695777430e-05
		,2.5677650720e-05
		,2.6795151640e-05
		,2.8070604430e-05
		,2.9528060880e-05
		,3.1192433910e-05
		,3.3089834940e-05
		,3.5249571900e-05
		,3.7698792480e-05
		,4.0461064120e-05
		,4.3554974500e-05
		,4.6991815910e-05
		,5.0780905710e-05
		,5.4926138200e-05
		,5.9427138870e-05
		,6.4279408450e-05
		,6.9475788470e-05
		,7.5009998490e-05
		,8.0872619030e-05
		,8.7052628430e-05
		,9.3535990610e-05
		,1.0031016080e-04
		,1.0736252820e-04
		,1.1468210010e-04
		,1.2226161330e-04
		,1.3009765620e-04
		,1.3819007750e-04
		////////////////////////////////
		,4.5948707670e-18
		,4.4750240810e-07
		,8.2108274470e-07
		,1.1436350320e-06
		,1.4320098100e-06
		,1.6946912300e-06
		,1.9383997120e-06
		,2.1716490080e-06
		,2.4002665970e-06
		,2.6266015570e-06
		,2.8528253150e-06
		,3.0829476440e-06
		,3.3207180590e-06
		,3.5668339690e-06
		,3.8165279700e-06
		,4.0632478490e-06
		,4.3047483540e-06
		,4.5436707920e-06
		,4.7857022090e-06
		,5.0357481370e-06
		,5.2944664520e-06
		,5.5600338140e-06
		,5.8348212510e-06
		,6.1204210050e-06
		,6.4138199920e-06
		,6.7122277690e-06
		,7.0173026150e-06
		,7.3278001550e-06
		,7.6424280720e-06
		,7.9605152940e-06
		,8.2820414180e-06
		,8.6072649380e-06
		,8.9365546380e-06
		,9.2704805320e-06
		,9.6097655940e-06
		,9.9550924420e-06
		,1.0306989550e-05
		,1.0665911230e-05
		,1.1031961300e-05
		,1.1404452580e-05
		,1.1781802830e-05
		,1.2162320340e-05
		,1.2545328710e-05
		,1.2930825770e-05
		,1.3318422120e-05
		,1.3706946920e-05
		,1.4094799930e-05
		,1.4480562770e-05
		,1.4863223470e-05
		,1.5242241350e-05
		,1.5616944780e-05
		,1.5986744280e-05
		,1.6351682490e-05
		,1.6712402390e-05
		,1.7069840090e-05
		,1.7424975060e-05
		,1.7778650300e-05
		,1.8131414880e-05
		,1.8483455420e-05
		,1.8834678470e-05
		,1.9184892920e-05
		,1.9533988610e-05
		,1.9882004260e-05
		,2.0229024880e-05
		,2.0574963030e-05
		,2.0919389180e-05
		,2.1261628790e-05
		,2.1601200200e-05
		,2.1938163750e-05
		,2.2272908670e-05
		,2.2605759140e-05
		,2.2936787940e-05
		,2.3265718650e-05
		,2.3592091220e-05
		,2.3915597270e-05
		,2.4236271030e-05
		,2.4554342670e-05
		,2.4869986700e-05
		,2.5183244930e-05
		,2.5494117150e-05
		,2.5802659270e-05
		,2.6109085570e-05
		,2.6413595600e-05
		,2.6716360860e-05
		,2.7017554750e-05
		,2.7317395370e-05
		,2.7616164810e-05
		,2.7914222280e-05
		,2.8212032450e-05
		,2.8510209940e-05
		,2.8809571160e-05
		,2.9111192250e-05
		,2.9416478240e-05
		,2.9727222900e-05
		,3.0045568800e-05
		,3.0374776770e-05
		,3.0719026130e-05
		,3.1083528910e-05
		,3.1474894530e-05
		,3.1901438450e-05
		,3.2373498910e-05
		,3.2903740280e-05
		,3.3507416320e-05
		,3.4202546580e-05
		,3.5009953180e-05
		,3.5953107190e-05
		,3.7057748790e-05
		,3.8351275640e-05
		,3.9861844870e-05
		,4.1617440980e-05
		,4.3645022220e-05
		,4.5969187030e-05
		,4.8611401890e-05
		,5.1589439650e-05
		,5.4916957470e-05
		,5.8603454730e-05
		,6.2655956320e-05
		,6.7078281800e-05
		,7.1872149250e-05
		,7.7036790280e-05
		,8.2571392680e-05
		////////////////////////////////
		,-6.9971632580e-18
		,1.3740770600e-06
		,2.5879706550e-06
		,3.6671853430e-06
		,4.6147631370e-06
		,5.4450918830e-06
		,6.1966153840e-06
		,6.8953731120e-06
		,7.5565977600e-06
		,8.1896411950e-06
		,8.7988008340e-06
		,9.3837762380e-06
		,9.9436278360e-06
		,1.0481076740e-05
		,1.0997839300e-05
		,1.1493419800e-05
		,1.1972563260e-05
		,1.2440648920e-05
		,1.2898700040e-05
		,1.3346971110e-05
		,1.3782160160e-05
		,1.4206363100e-05
		,1.4628237080e-05
		,1.5051749390e-05
		,1.5476446670e-05
		,1.5897856320e-05
		,1.6305687370e-05
		,1.6694163350e-05
		,1.7073242470e-05
		,1.7451246000e-05
		,1.7828512910e-05
		,1.8202454340e-05
		,1.8569195790e-05
		,1.8931061580e-05
		,1.9291919250e-05
		,1.9653256420e-05
		,2.0015481410e-05
		,2.0379545140e-05
		,2.0745928300e-05
		,2.1114758670e-05
		,2.1486312960e-05
		,2.1860475210e-05
		,2.2236422520e-05
		,2.2612136610e-05
		,2.2983617000e-05
		,2.3346348720e-05
		,2.3699558600e-05
		,2.4045818120e-05
		,2.4387940970e-05
		,2.4727741170e-05
		,2.5065882860e-05
		,2.5402160050e-05
		,2.5736156570e-05
		,2.6067229030e-05
		,2.6394241110e-05
		,2.6716012670e-05
		,2.7031682690e-05
		,2.7341188420e-05
		,2.7644631590e-05
		,2.7941625820e-05
		,2.8231607700e-05
		,2.8514439710e-05
		,2.8790249050e-05
		,2.9058981160e-05
		,2.9320545350e-05
		,2.9575184520e-05
		,2.9823540450e-05
		,3.0066532290e-05
		,3.0305187430e-05
		,3.0540418100e-05
		,3.0772861640e-05
		,3.1002873210e-05
		,3.1230594760e-05
		,3.1456000900e-05
		,3.1678903510e-05
		,3.1898943120e-05
		,3.2115639660e-05
		,3.2328570630e-05
		,3.2537508180e-05
		,3.2742440150e-05
		,3.2943467310e-05
		,3.3140674080e-05
		,3.3334068560e-05
		,3.3523576520e-05
		,3.3709077090e-05
		,3.3890503360e-05
		,3.4067950630e-05
		,3.4241706270e-05
		,3.4412106550e-05
		,3.4579407010e-05
		,3.4743783080e-05
		,3.4905403120e-05
		,3.5064501460e-05
		,3.5221378480e-05
		,3.5376358200e-05
		,3.5529782690e-05
		,3.5682052290e-05
		,3.5833669570e-05
		,3.5985265910e-05
		,3.6137633610e-05
		,3.6291780190e-05
		,3.6448987520e-05
		,3.6610774450e-05
		,3.6779402240e-05
		,3.6957813690e-05
		,3.7149689920e-05
		,3.7359739800e-05
		,3.7593956560e-05
		,3.7859899030e-05
		,3.8166994730e-05
		,3.8526848070e-05
		,3.8953525440e-05
		,3.9463778870e-05
		,4.0077161650e-05
		,4.0815988400e-05
		,4.1705103470e-05
		,4.2771432450e-05
		,4.4043318990e-05
		,4.5549766110e-05
		,4.7319394130e-05
		,4.9379391640e-05
		////////////////////////////////
		,-9.5035489940e-18
		,2.5566198950e-06
		,4.8386512320e-06
		,6.8686408510e-06
		,8.6770148450e-06
		,1.0292675080e-05
		,1.1735251630e-05
		,1.3008384890e-05
		,1.4112549650e-05
		,1.5059900840e-05
		,1.5888710650e-05
		,1.6637067560e-05
		,1.7325257710e-05
		,1.7964260430e-05
		,1.8562535270e-05
		,1.9128514930e-05
		,1.9666329710e-05
		,2.0172988230e-05
		,2.0652135060e-05
		,2.1113267250e-05
		,2.1560639640e-05
		,2.1995768180e-05
		,2.2419238680e-05
		,2.2831151730e-05
		,2.3231239970e-05
		,2.3619113530e-05
		,2.3994881030e-05
		,2.4359474630e-05
		,2.4713823000e-05
		,2.5058317010e-05
		,2.5393099050e-05
		,2.5716787090e-05
		,2.6027699470e-05
		,2.6329250060e-05
		,2.6624769320e-05
		,2.6914972120e-05
		,2.7200209900e-05
		,2.7481391690e-05
		,2.7758694860e-05
		,2.8030357560e-05
		,2.8295036640e-05
		,2.8555582480e-05
		,2.8812820860e-05
		,2.9066580830e-05
		,2.9316835220e-05
		,2.9563408800e-05
		,2.9806017940e-05
		,3.0044738360e-05
		,3.0279757690e-05
		,3.0511205750e-05
		,3.0739151410e-05
		,3.0963778080e-05
		,3.1185270540e-05
		,3.1403686670e-05
		,3.1619033700e-05
		,3.1831388910e-05
		,3.2040827510e-05
		,3.2247344600e-05
		,3.2450855130e-05
		,3.2651163200e-05
		,3.2848046040e-05
		,3.3041530390e-05
		,3.3231581610e-05
		,3.3417955400e-05
		,3.3600436610e-05
		,3.3779035140e-05
		,3.3953934210e-05
		,3.4125302930e-05
		,3.4293192160e-05
		,3.4457582860e-05
		,3.4618452480e-05
		,3.4775837290e-05
		,3.4929853790e-05
		,3.5080669400e-05
		,3.5228449370e-05
		,3.5373306430e-05
		,3.5515267410e-05
		,3.5654292540e-05
		,3.5790365840e-05
		,3.5923541570e-05
		,3.6053922320e-05
		,3.6181627480e-05
		,3.6306769460e-05
		,3.6429468210e-05
		,3.6549840900e-05
		,3.6667967580e-05
		,3.6783888060e-05
		,3.6897606370e-05
		,3.7009098750e-05
		,3.7118330870e-05
		,3.7225292280e-05
		,3.7330040910e-05
		,3.7432719280e-05
		,3.7533519110e-05
		,3.7632646120e-05
		,3.7730265110e-05
		,3.7826499920e-05
		,3.7921451310e-05
		,3.8015225620e-05
		,3.8107956450e-05
		,3.8199804950e-05
		,3.8290950180e-05
		,3.8381588680e-05
		,3.8471949460e-05
		,3.8562317880e-05
		,3.8653055010e-05
		,3.8744611490e-05
		,3.8837552270e-05
		,3.8932597770e-05
		,3.9030667810e-05
		,3.9132840500e-05
		,3.9240702780e-05
		,3.9356339540e-05
		,3.9482362060e-05
		,3.9622128920e-05
		,3.9779949810e-05
		,3.9961321630e-05
		,4.0173199240e-05
		,4.0424294590e-05
		,4.0725390770e-05
		,4.1089646010e-05
		////////////////////////////////
		,-1.4464104100e-17
		,3.2630271540e-06
		,6.2196722550e-06
		,8.8895587480e-06
		,1.1292321900e-05
		,1.3447883330e-05
		,1.5376117810e-05
		,1.7096441570e-05
		,1.8627448950e-05
		,1.9986526500e-05
		,2.1189431890e-05
		,2.2249606860e-05
		,2.3177506260e-05
		,2.3984864520e-05
		,2.4690762240e-05
		,2.5314482280e-05
		,2.5870102920e-05
		,2.6368762930e-05
		,2.6818827920e-05
		,2.7224722050e-05
		,2.7594516170e-05
		,2.7940521240e-05
		,2.8269684140e-05
		,2.8584833620e-05
		,2.8887158290e-05
		,2.9177263250e-05
		,2.9455825980e-05
		,2.9723059230e-05
		,2.9978836290e-05
		,3.0222359180e-05
		,3.0452166120e-05
		,3.0670550910e-05
		,3.0881853370e-05
		,3.1088610390e-05
		,3.1291949330e-05
		,3.1492206240e-05
		,3.1689160870e-05
		,3.1881734980e-05
		,3.2068894850e-05
		,3.2251916010e-05
		,3.2432035950e-05
		,3.2609634680e-05
		,3.2784745520e-05
		,3.2957182990e-05
		,3.3126510160e-05
		,3.3292504850e-05
		,3.3455799880e-05
		,3.3615502240e-05
		,3.3772041680e-05
		,3.3926869370e-05
		,3.4080108800e-05
		,3.4231631620e-05
		,3.4381347570e-05
		,3.4529148390e-05
		,3.4674883710e-05
		,3.4818390360e-05
		,3.4959540880e-05
		,3.5098297420e-05
		,3.5234718090e-05
		,3.5368910770e-05
		,3.5501069060e-05
		,3.5631367710e-05
		,3.5759881800e-05
		,3.5886623080e-05
		,3.6011535580e-05
		,3.6134469980e-05
		,3.6255272640e-05
		,3.6374028740e-05
		,3.6490860890e-05
		,3.6605805120e-05
		,3.6718884210e-05
		,3.6830134730e-05
		,3.6939605500e-05
		,3.7047338540e-05
		,3.7153363910e-05
		,3.7257719540e-05
		,3.7360454330e-05
		,3.7461625940e-05
		,3.7561299840e-05
		,3.7659548050e-05
		,3.7756452730e-05
		,3.7852099590e-05
		,3.7946566050e-05
		,3.8039913560e-05
		,3.8132186510e-05
		,3.8223426580e-05
		,3.8313678070e-05
		,3.8402971270e-05
		,3.8491319880e-05
		,3.8578753360e-05
		,3.8665330110e-05
		,3.8751106540e-05
		,3.8836125590e-05
		,3.8920421830e-05
		,3.9004027050e-05
		,3.9086970960e-05
		,3.9169281310e-05
		,3.9250984560e-05
		,3.9332104890e-05
		,3.9412652220e-05
		,3.9492617100e-05
		,3.9571958680e-05
		,3.9650633210e-05
		,3.9728639630e-05
		,3.9806042590e-05
		,3.9882955310e-05
		,3.9959507370e-05
		,4.0035824100e-05
		,4.0112022620e-05
		,4.0188218150e-05
		,4.0264533800e-05
		,4.0341111570e-05
		,4.0418124230e-05
		,4.0495789280e-05
		,4.0574386060e-05
		,4.0654277280e-05
		,4.0735935680e-05
		,4.0819970800e-05
		,4.0907083750e-05
		,4.0998367430e-05
		,4.1095277450e-05
		////////////////////////////////
		,9.2943440170e-18
		,3.7512590900e-06
		,7.1460947420e-06
		,1.0204403520e-05
		,1.2946403710e-05
		,1.5392538270e-05
		,1.7564005570e-05
		,1.9483469640e-05
		,2.1174331500e-05
		,2.2659458230e-05
		,2.3960095040e-05
		,2.5094265520e-05
		,2.6075742160e-05
		,2.6920902690e-05
		,2.7652823000e-05
		,2.8291840690e-05
		,2.8854782520e-05
		,2.9356329450e-05
		,2.9808219750e-05
		,3.0219301320e-05
		,3.0596255470e-05
		,3.0944210200e-05
		,3.1267120160e-05
		,3.1567999680e-05
		,3.1849117040e-05
		,3.2112282720e-05
		,3.2359365940e-05
		,3.2592399920e-05
		,3.2813065750e-05
		,3.3022723360e-05
		,3.3222626890e-05
		,3.3413487150e-05
		,3.3595790850e-05
		,3.3771310280e-05
		,3.3941922470e-05
		,3.4108730810e-05
		,3.4272283290e-05
		,3.4432987850e-05
		,3.4591141400e-05
		,3.4746821690e-05
		,3.4900000950e-05
		,3.5050463380e-05
		,3.5197361200e-05
		,3.5338809180e-05
		,3.5474718710e-05
		,3.5607283600e-05
		,3.5737626740e-05
		,3.5866063130e-05
		,3.5992692380e-05
		,3.6117532220e-05
		,3.6240554490e-05
		,3.6361706530e-05
		,3.6480914960e-05
		,3.6598021080e-05
		,3.6712367020e-05
		,3.6822835050e-05
		,3.6930394140e-05
		,3.7035602810e-05
		,3.7138318240e-05
		,3.7238719240e-05
		,3.7337237260e-05
		,3.7434134150e-05
		,3.7529578610e-05
		,3.7623693850e-05
		,3.7716575770e-05
		,3.7808306460e-05
		,3.7898960320e-05
		,3.7988594760e-05
		,3.8077251770e-05
		,3.8164962350e-05
		,3.8251729250e-05
		,3.8337484630e-05
		,3.8422138740e-05
		,3.8505814650e-05
		,3.8588730060e-05
		,3.8671008430e-05
		,3.8752709410e-05
		,3.8833876740e-05
		,3.8914548600e-05
		,3.8994761690e-05
		,3.9074542700e-05
		,3.9153903110e-05
		,3.9232855120e-05
		,3.9311422430e-05
		,3.9389637010e-05
		,3.9467521440e-05
		,3.9545075340e-05
		,3.9622296530e-05
		,3.9699192700e-05
		,3.9775779400e-05
		,3.9852079430e-05
		,3.9928117560e-05
		,4.0003899780e-05
		,4.0079416530e-05
		,4.0154660150e-05
		,4.0229643380e-05
		,4.0304418500e-05
		,4.0379046150e-05
		,4.0453570960e-05
		,4.0528012710e-05
		,4.0602377460e-05
		,4.0676673380e-05
		,4.0750906080e-05
		,4.0825066540e-05
		,4.0899140100e-05
		,4.0973119500e-05
		,4.1047011690e-05
		,4.1120834450e-05
		,4.1194600300e-05
		,4.1268309640e-05
		,4.1341963630e-05
		,4.1415572150e-05
		,4.1489153550e-05
		,4.1562735190e-05
		,4.1636356480e-05
		,4.1710072250e-05
		,4.1783951730e-05
		,4.1858073380e-05
		,4.1932518140e-05
		,4.2007364760e-05
		,4.2082699680e-05
		////////////////////////////////
		,-3.3420174050e-18
		,1.8615448850e-14
		,3.1813345100e-14
		,4.1219340820e-14
		,4.8031645030e-14
		,5.3013034460e-14
		,5.6757731400e-14
		,5.9613757940e-14
		,6.1881149350e-14
		,6.3722872920e-14
		,6.5297979710e-14
		,6.6665421990e-14
		,6.7880026960e-14
		,6.8979077110e-14
		,7.0024762120e-14
		,7.1028517390e-14
		,7.1957759900e-14
		,7.2889822100e-14
		,7.3772017660e-14
		,7.4608732770e-14
		,7.5434221350e-14
		,7.6254018350e-14
		,7.7065304080e-14
		,7.7847505300e-14
		,7.8555715920e-14
		,7.9326481750e-14
		,8.0020385080e-14
		,8.0712147540e-14
		,8.1448868300e-14
		,8.2137445570e-14
		,8.2797512690e-14
		,8.3468023090e-14
		,8.4112790820e-14
		,8.4804448850e-14
		,8.5463367220e-14
		,8.6159620290e-14
		,8.6795511240e-14
		,8.7473801880e-14
		,8.8142014760e-14
		,8.8825527030e-14
		,8.9512381160e-14
		,9.0208216500e-14
		,9.0863793020e-14
		,9.1596754200e-14
		,9.2279274360e-14
		,9.2996779490e-14
		,9.3730732780e-14
		,9.4423017410e-14
		,9.5135405340e-14
		,9.5852388310e-14
		,9.6594226270e-14
		,9.7312775730e-14
		,9.8052472820e-14
		,9.8801359990e-14
		,9.9570872630e-14
		,1.0030263280e-13
		,1.0108410300e-13
		,1.0184954280e-13
		,1.0262182290e-13
		,1.0340731370e-13
		,1.0423181020e-13
		,1.0505562790e-13
		,1.0590544930e-13
		,1.0678237100e-13
		,1.0759987050e-13
		,1.0851219490e-13
		,1.0942196070e-13
		,1.1043694250e-13
		,1.1147474280e-13
		,1.1255118330e-13
		,1.1377884230e-13
		,1.1503563810e-13
		,1.1652213370e-13
		,1.1811859700e-13
		,1.2009101820e-13
		,1.2236117700e-13
		,1.2512086440e-13
		,1.2849884580e-13
		,1.3260414890e-13
		,1.3782756120e-13
		,1.4453376180e-13
		,1.5310868180e-13
		,1.6430423690e-13
		,1.7897567910e-13
		,1.9784599620e-13
		,2.1960064120e-13
		,2.4703778470e-13
		,2.8248126420e-13
		,3.2847735870e-13
		,3.8833178200e-13
		,4.6667393320e-13
		,5.6945861910e-13
		,7.0503513280e-13
		,8.8453819740e-13
		,1.1229642500e-12
		,1.4376858850e-12
		,1.8233390200e-12
		,2.3251078360e-12
		,2.9786582550e-12
		,3.8305013820e-12
		,4.9417674420e-12
		,6.3897348870e-12
		,8.2752814080e-12
		,1.0738407290e-11
		,1.3959648440e-11
		,1.8175477230e-11
		,2.3696496730e-11
		,3.0931658350e-11
		,4.0419331220e-11
		,5.2868298740e-11
		,6.9212470980e-11
		,9.0682936520e-11
		,1.1890323960e-10
		,1.5601521060e-10
		,2.0484584410e-10
		,2.6909792890e-10
		,3.5369406700e-10
		,4.6515436190e-10
		,6.1208026640e-10
		,8.0584631810e-10
		,1.0615014110e-09
		////////////////////////////////
		,3.4880365060e-17
		,4.3604193260e-06
		,8.2877058850e-06
		,1.1795096210e-05
		,1.4897792470e-05
		,1.7610293760e-05
		,1.9959688100e-05
		,2.1988591000e-05
		,2.3738131110e-05
		,2.5245701260e-05
		,2.6545660080e-05
		,2.7669189580e-05
		,2.8644000790e-05
		,2.9494132800e-05
		,3.0239734260e-05
		,3.0896170560e-05
		,3.1474044050e-05
		,3.1989013070e-05
		,3.2455909440e-05
		,3.2882932150e-05
		,3.3274351820e-05
		,3.3629995040e-05
		,3.3949075880e-05
		,3.4242665780e-05
		,3.4518633300e-05
		,3.4779987300e-05
		,3.5028356860e-05
		,3.5264852100e-05
		,3.5490314480e-05
		,3.5705426740e-05
		,3.5910775460e-05
		,3.6106890970e-05
		,3.6294273350e-05
		,3.6473409230e-05
		,3.6644783520e-05
		,3.6808887980e-05
		,3.6966223310e-05
		,3.7117291610e-05
		,3.7262583670e-05
		,3.7402568280e-05
		,3.7537685550e-05
		,3.7668343330e-05
		,3.7794915480e-05
		,3.7917741280e-05
		,3.8037125480e-05
		,3.8153338190e-05
		,3.8266613820e-05
		,3.8377148030e-05
		,3.8485093080e-05
		,3.8590557510e-05
		,3.8693624420e-05
		,3.8794399100e-05
		,3.8893014360e-05
		,3.8989500990e-05
		,3.9083956450e-05
		,3.9176755730e-05
		,3.9268154410e-05
		,3.9358187110e-05
		,3.9446867300e-05
		,3.9534326370e-05
		,3.9620768360e-05
		,3.9706437200e-05
		,3.9791380220e-05
		,3.9875525210e-05
		,3.9958757450e-05
		,4.0041088900e-05
		,4.0122715590e-05
		,4.0203829990e-05
		,4.0284449250e-05
		,4.0364111630e-05
		,4.0441879970e-05
		,4.0518618950e-05
		,4.0595209190e-05
		,4.0671809680e-05
		,4.0748431180e-05
		,4.0825061040e-05
		,4.0901685250e-05
		,4.0978292380e-05
		,4.1054873790e-05
		,4.1131422440e-05
		,4.1207930090e-05
		,4.1284378760e-05
		,4.1360711160e-05
		,4.1436755870e-05
		,4.1512268090e-05
		,4.1587224740e-05
		,4.1661796440e-05
		,4.1736231310e-05
		,4.1810639750e-05
		,4.1885054690e-05
		,4.1959474290e-05
		,4.2033882050e-05
		,4.2108264440e-05
		,4.2182612610e-05
		,4.2256919260e-05
		,4.2331183560e-05
		,4.2405421020e-05
		,4.2479650820e-05
		,4.2553870290e-05
		,4.2628057020e-05
		,4.2702189730e-05
		,4.2776254890e-05
		,4.2850262770e-05
		,4.2924220130e-05
		,4.2998127200e-05
		,4.3071980610e-05
		,4.3145771800e-05
		,4.3219498290e-05
		,4.3293185960e-05
		,4.3366868940e-05
		,4.3440565800e-05
		,4.3514285720e-05
		,4.3588040620e-05
		,4.3661844790e-05
		,4.3735700690e-05
		,4.3809597160e-05
		,4.3883523300e-05
		,4.3957469250e-05
		,4.4031429000e-05
		,4.4105418560e-05
		,4.4179466230e-05
		////////////////////////////////
		,-7.4671105870e-18
		,4.5654646430e-06
		,8.6552665140e-06
		,1.2276119920e-05
		,1.5447066160e-05
		,1.8205153760e-05
		,2.0591562400e-05
		,2.2647587480e-05
		,2.4413955000e-05
		,2.5929847110e-05
		,2.7231883860e-05
		,2.8353271200e-05
		,2.9323063350e-05
		,3.0164829920e-05
		,3.0895517110e-05
		,3.1537344850e-05
		,3.2111656320e-05
		,3.2628619790e-05
		,3.3086137360e-05
		,3.3490201870e-05
		,3.3861056650e-05
		,3.4207420260e-05
		,3.4533497060e-05
		,3.4841952530e-05
		,3.5134618940e-05
		,3.5412776180e-05
		,3.5677302900e-05
		,3.5928742390e-05
		,3.6167342660e-05
		,3.6393454780e-05
		,3.6607949440e-05
		,3.6811781400e-05
		,3.7005777790e-05
		,3.7190707080e-05
		,3.7367315490e-05
		,3.7536327380e-05
		,3.7698434360e-05
		,3.7854283930e-05
		,3.8004471460e-05
		,3.8149536240e-05
		,3.8289960690e-05
		,3.8426170860e-05
		,3.8558535400e-05
		,3.8687357450e-05
		,3.8812840410e-05
		,3.8934964180e-05
		,3.9053272810e-05
		,3.9167682710e-05
		,3.9279236180e-05
		,3.9388675600e-05
		,3.9496315780e-05
		,3.9602321660e-05
		,3.9706803410e-05
		,3.9809842430e-05
		,3.9911493450e-05
		,4.0011768240e-05
		,4.0110590090e-05
		,4.0207758790e-05
		,4.0303196930e-05
		,4.0397219660e-05
		,4.0490150940e-05
		,4.0582128860e-05
		,4.0673183210e-05
		,4.0763299200e-05
		,4.0852471810e-05
		,4.0940760080e-05
		,4.1028266120e-05
		,4.1115076020e-05
		,4.1201243050e-05
		,4.1286776660e-05
		,4.1371589390e-05
		,4.1455505440e-05
		,4.1538780120e-05
		,4.1621759230e-05
		,4.1704580030e-05
		,4.1787273200e-05
		,4.1869661950e-05
		,4.1950830450e-05
		,4.2030486750e-05
		,4.2109740430e-05
		,4.2188907210e-05
		,4.2267985780e-05
		,4.2346889850e-05
		,4.2425523540e-05
		,4.2503982680e-05
		,4.2582412680e-05
		,4.2660863890e-05
		,4.2739332490e-05
		,4.2817756800e-05
		,4.2895965080e-05
		,4.2973802680e-05
		,4.3051358300e-05
		,4.3128746540e-05
		,4.3206012640e-05
		,4.3283170750e-05
		,4.3360224990e-05
		,4.3437176300e-05
		,4.3514021210e-05
		,4.3590736830e-05
		,4.3667264300e-05
		,4.3743631840e-05
		,4.3819938510e-05
		,4.3896222240e-05
		,4.3972498020e-05
		,4.4048780930e-05
		,4.4125075190e-05
		,4.4201364440e-05
		,4.4277635520e-05
		,4.4353891080e-05
		,4.4430130720e-05
		,4.4506352160e-05
		,4.4582548950e-05
		,4.4658701300e-05
		,4.4734770380e-05
		,4.4810739200e-05
		,4.4886638870e-05
		,4.4962515060e-05
		,4.5038387570e-05
		,4.5114261510e-05
		,4.5190138660e-05
		,4.5266020920e-05
		////////////////////////////////
		,-9.2424671500e-18
		,4.7237975050e-06
		,8.9257992730e-06
		,1.2625821580e-05
		,1.5858043430e-05
		,1.8661946620e-05
		,2.1079755310e-05
		,2.3154989610e-05
		,2.4930978550e-05
		,2.6449390630e-05
		,2.7748904370e-05
		,2.8863875990e-05
		,2.9821867930e-05
		,3.0645756280e-05
		,3.1365855850e-05
		,3.2001760410e-05
		,3.2554321540e-05
		,3.3038206790e-05
		,3.3476616760e-05
		,3.3881041790e-05
		,3.4258054500e-05
		,3.4612039480e-05
		,3.4946087700e-05
		,3.5262397370e-05
		,3.5562531960e-05
		,3.5847621960e-05
		,3.6118534710e-05
		,3.6376015350e-05
		,3.6620793170e-05
		,3.6853645670e-05
		,3.7075418920e-05
		,3.7287011980e-05
		,3.7489339990e-05
		,3.7683291520e-05
		,3.7869689670e-05
		,3.8049257400e-05
		,3.8222568190e-05
		,3.8389887090e-05
		,3.8550420850e-05
		,3.8702497720e-05
		,3.8848386300e-05
		,3.8990127930e-05
		,3.9128506880e-05
		,3.9263908540e-05
		,3.9396581210e-05
		,3.9526718080e-05
		,3.9654485030e-05
		,3.9780031100e-05
		,3.9903492830e-05
		,4.0024996180e-05
		,4.0144657460e-05
		,4.0262583820e-05
		,4.0378873710e-05
		,4.0493617010e-05
		,4.0606894960e-05
		,4.0718779140e-05
		,4.0829329200e-05
		,4.0938587070e-05
		,4.1046563190e-05
		,4.1153203350e-05
		,4.1258329930e-05
		,4.1361674470e-05
		,4.1463245170e-05
		,4.1563428620e-05
		,4.1662558970e-05
		,4.1760800030e-05
		,4.1858225450e-05
		,4.1954872630e-05
		,4.2050764840e-05
		,4.2145919740e-05
		,4.2240352680e-05
		,4.2334077730e-05
		,4.2427107500e-05
		,4.2519451890e-05
		,4.2611115700e-05
		,4.2702095760e-05
		,4.2792382580e-05
		,4.2881977730e-05
		,4.2970928110e-05
		,4.3059322570e-05
		,4.3147240720e-05
		,4.3234710800e-05
		,4.3321597110e-05
		,4.3407638850e-05
		,4.3492449750e-05
		,4.3575125140e-05
		,4.3656839250e-05
		,4.3738421400e-05
		,4.3819996120e-05
		,4.3901560230e-05
		,4.3983093550e-05
		,4.4064576660e-05
		,4.4145991110e-05
		,4.4227310540e-05
		,4.4308474510e-05
		,4.4389363400e-05
		,4.4469902070e-05
		,4.4550143050e-05
		,4.4630199070e-05
		,4.4710137540e-05
		,4.4789981390e-05
		,4.4869737600e-05
		,4.4949407910e-05
		,4.5028992130e-05
		,4.5108489300e-05
		,4.5187898220e-05
		,4.5267217580e-05
		,4.5346446160e-05
		,4.5425582900e-05
		,4.5504627190e-05
		,4.5583578950e-05
		,4.5662437540e-05
		,4.5741195010e-05
		,4.5819838090e-05
		,4.5898411220e-05
		,4.5976969340e-05
		,4.6055522940e-05
		,4.6134061620e-05
		,4.6212553140e-05
		,4.6290951490e-05
		,4.6369261600e-05
		////////////////////////////////
		,-2.0260121100e-17
		,1.4474892070e-09
		,2.6928186330e-09
		,3.8022777460e-09
		,4.8245976560e-09
		,5.7961134260e-09
		,6.7485172590e-09
		,7.7111226000e-09
		,8.7085252440e-09
		,9.7588981680e-09
		,1.0871930640e-08
		,1.2045170020e-08
		,1.3263290030e-08
		,1.4511047440e-08
		,1.5790139340e-08
		,1.7114132820e-08
		,1.8496521530e-08
		,1.9950439210e-08
		,2.1494064500e-08
		,2.3150149680e-08
		,2.4940479630e-08
		,2.6883037480e-08
		,2.8992373740e-08
		,3.1281517660e-08
		,3.3764519260e-08
		,3.6457382190e-08
		,3.9376582820e-08
		,4.2537160810e-08
		,4.5949218390e-08
		,4.9617732570e-08
		,5.3550505360e-08
		,5.7767209120e-08
		,6.2298216550e-08
		,6.7178024950e-08
		,7.2440993040e-08
		,7.8120504240e-08
		,8.4251682810e-08
		,9.0875463970e-08
		,9.8039360930e-08
		,1.0579545390e-07
		,1.1419841150e-07
		,1.2330355610e-07
		,1.3316378340e-07
		,1.4382405520e-07
		,1.5531394470e-07
		,1.6764576640e-07
		,1.8083362220e-07
		,1.9492697460e-07
		,2.1001564600e-07
		,2.2620285480e-07
		,2.4358232420e-07
		,2.6223083560e-07
		,2.8221079740e-07
		,3.0357737840e-07
		,3.2637403600e-07
		,3.5060836150e-07
		,3.7622609230e-07
		,4.0313543140e-07
		,4.3129420490e-07
		,4.6086008100e-07
		,4.9217236150e-07
		,5.2566519100e-07
		,5.6200481450e-07
		,6.0197917850e-07
		,6.4648434980e-07
		,6.9677219790e-07
		,7.5435739790e-07
		,8.2112714960e-07
		,8.9960670110e-07
		,9.9300920140e-07
		,1.1043247700e-06
		,1.2390296710e-06
		,1.4034566360e-06
		,1.6052626090e-06
		,1.8537647950e-06
		,2.1582677890e-06
		,2.5329725320e-06
		,2.9939877910e-06
		,3.5600756730e-06
		,4.2532077160e-06
		,5.0977164040e-06
		,6.1215215150e-06
		,7.3541477420e-06
		,8.8213735450e-06
		,1.0540147420e-05
		,1.2563791440e-05
		,1.4936178180e-05
		,1.7700099800e-05
		,2.0892526850e-05
		,2.4541436280e-05
		,2.8609491220e-05
		,3.2868766330e-05
		,3.7457059730e-05
		,4.2201928680e-05
		,4.7385550430e-05
		,5.3085962540e-05
		,5.9346227210e-05
		,6.6186777440e-05
		,7.3621280380e-05
		,8.1657633510e-05
		,9.0299204320e-05
		,9.9543697420e-05
		,1.0938220160e-04
		,1.1979915490e-04
		,1.3077201730e-04
		,1.4227123270e-04
		,1.5426071680e-04
		,1.6669837080e-04
		,1.7953672500e-04
		,1.9272410630e-04
		,2.0612677680e-04
		,2.1967950640e-04
		,2.3341147580e-04
		,2.4728207200e-04
		,2.6124776060e-04
		,2.7526594580e-04
		,2.8929869930e-04
		,3.0315578490e-04
		,3.1691610570e-04
		,3.3041779490e-04
		,3.4352999180e-04
		////////////////////////////////
		,-7.6759760570e-18
		,5.8546847560e-09
		,1.0822562740e-08
		,1.5137095350e-08
		,1.8976601590e-08
		,2.2479542250e-08
		,2.5778408130e-08
		,2.9003354150e-08
		,3.2259071680e-08
		,3.5629711570e-08
		,3.9178057800e-08
		,4.2955337320e-08
		,4.7014759500e-08
		,5.1411050950e-08
		,5.6195092080e-08
		,6.1410040240e-08
		,6.7087931820e-08
		,7.3247444660e-08
		,7.9897821520e-08
		,8.7061558720e-08
		,9.4799454510e-08
		,1.0319881810e-07
		,1.1234769390e-07
		,1.2232383290e-07
		,1.3318938460e-07
		,1.4498328280e-07
		,1.5771528370e-07
		,1.7136531360e-07
		,1.8588055980e-07
		,2.0119097080e-07
		,2.1728269670e-07
		,2.3427320830e-07
		,2.5238193780e-07
		,2.7182807210e-07
		,2.9273124980e-07
		,3.1504902550e-07
		,3.3853551610e-07
		,3.6277693420e-07
		,3.8738595280e-07
		,4.1225270870e-07
		,4.3759194860e-07
		,4.6377008870e-07
		,4.9113590030e-07
		,5.1996720900e-07
		,5.5049185550e-07
		,5.8291417230e-07
		,6.1741782990e-07
		,6.5415641220e-07
		,6.9325237350e-07
		,7.3481982440e-07
		,7.7900623610e-07
		,8.2601310250e-07
		,8.7608043090e-07
		,9.2947159730e-07
		,9.8646951510e-07
		,1.0473716910e-06
		,1.1124912740e-06
		,1.1821615810e-06
		,1.2567408140e-06
		,1.3366167450e-06
		,1.4222117590e-06
		,1.5139886830e-06
		,1.6124506780e-06
		,1.7181621040e-06
		,1.8317505000e-06
		,1.9539214670e-06
		,2.0854885430e-06
		,2.2274128110e-06
		,2.3808964860e-06
		,2.5474582360e-06
		,2.7290616730e-06
		,2.9281614040e-06
		,3.1478249780e-06
		,3.3919299420e-06
		,3.6653808430e-06
		,3.9750493990e-06
		,4.3299046560e-06
		,4.7427738250e-06
		,5.2288984800e-06
		,5.8064634460e-06
		,6.4966730680e-06
		,7.3219153840e-06
		,8.3050140300e-06
		,9.4751650460e-06
		,1.0854058910e-05
		,1.2442406870e-05
		,1.4228185040e-05
		,1.6243446350e-05
		,1.8468759800e-05
		,2.0941397250e-05
		,2.3738594130e-05
		,2.6910900640e-05
		,3.0493725430e-05
		,3.4513625350e-05
		,3.8994481740e-05
		,4.3960528130e-05
		,4.9430620830e-05
		,5.5420459090e-05
		,6.1942229400e-05
		,6.9004206540e-05
		,7.6610190490e-05
		,8.4757774100e-05
		,9.3442935430e-05
		,1.0265424590e-04
		,1.1237439180e-04
		,1.2257990240e-04
		,1.3324091850e-04
		,1.4432103850e-04
		,1.5577416140e-04
		,1.6749889540e-04
		,1.7949935050e-04
		,1.9175326360e-04
		,2.0422690890e-04
		,2.1688343520e-04
		,2.2968545190e-04
		,2.4259810260e-04
		,2.5559287680e-04
		,2.6858652430e-04
		,2.8134021230e-04
		,2.9405185060e-04
		,3.0663830630e-04
		////////////////////////////////
		,-1.8380331800e-17
		,2.3627620390e-08
		,4.3997192070e-08
		,6.2225157450e-08
		,7.9228405040e-08
		,9.5700944100e-08
		,1.1204612080e-07
		,1.2838258780e-07
		,1.4476013080e-07
		,1.6130424340e-07
		,1.7794299970e-07
		,1.9487263240e-07
		,2.1284882850e-07
		,2.3223537710e-07
		,2.5300746230e-07
		,2.7499174820e-07
		,2.9804261810e-07
		,3.2205208910e-07
		,3.4692436760e-07
		,3.7264032460e-07
		,3.9932913910e-07
		,4.2726021100e-07
		,4.5679697030e-07
		,4.8834186550e-07
		,5.2224399200e-07
		,5.5877581460e-07
		,5.9817007170e-07
		,6.4065557320e-07
		,6.8645299260e-07
		,7.3573506200e-07
		,7.8858040840e-07
		,8.4495974160e-07
		,9.0482088070e-07
		,9.6826566970e-07
		,1.0356352440e-06
		,1.1074122320e-06
		,1.1840721460e-06
		,1.2660165440e-06
		,1.3536862010e-06
		,1.4475972250e-06
		,1.5482129420e-06
		,1.6558898280e-06
		,1.7708614540e-06
		,1.8933055130e-06
		,2.0234804820e-06
		,2.1617525960e-06
		,2.3084470440e-06
		,2.4636788010e-06
		,2.6273037940e-06
		,2.7990715690e-06
		,2.9789295160e-06
		,3.1672249910e-06
		,3.3646301310e-06
		,3.5718894810e-06
		,3.7895935640e-06
		,4.0180710970e-06
		,4.2573704610e-06
		,4.5072415650e-06
		,4.7670154000e-06
		,5.0353901800e-06
		,5.3102219940e-06
		,5.5886055530e-06
		,5.8676622610e-06
		,6.1457826300e-06
		,6.4232030330e-06
		,6.7013020600e-06
		,6.9815920320e-06
		,7.2654484950e-06
		,7.5544793190e-06
		,7.8509720720e-06
		,8.1575787020e-06
		,8.4769214030e-06
		,8.8114577430e-06
		,9.1635065270e-06
		,9.5353670560e-06
		,9.9294633520e-06
		,1.0348514240e-05
		,1.0795722900e-05
		,1.1274977860e-05
		,1.1791157100e-05
		,1.2350650390e-05
		,1.2961397310e-05
		,1.3634034090e-05
		,1.4381790870e-05
		,1.5220900620e-05
		,1.6170693290e-05
		,1.7253868080e-05
		,1.8496869540e-05
		,1.9926240480e-05
		,2.1575782760e-05
		,2.3481006470e-05
		,2.5677147810e-05
		,2.8198658140e-05
		,3.1078156760e-05
		,3.4342129060e-05
		,3.8019093940e-05
		,4.2133633890e-05
		,4.6704897750e-05
		,5.1747566490e-05
		,5.7271537160e-05
		,6.3280357510e-05
		,6.9773511590e-05
		,7.6746158010e-05
		,8.4179334180e-05
		,9.2055179020e-05
		,1.0036201560e-04
		,1.0907494230e-04
		,1.1816556330e-04
		,1.2761479990e-04
		,1.3740424300e-04
		,1.4751039620e-04
		,1.5790495710e-04
		,1.6855596520e-04
		,1.7942937240e-04
		,1.9049311370e-04
		,2.0163531790e-04
		,2.1276265320e-04
		,2.2368046280e-04
		,2.3462571330e-04
		,2.4573343730e-04
		,2.5701863760e-04
		////////////////////////////////
		,-3.1329991430e-17
		,1.1336173710e-07
		,2.0831860400e-07
		,2.9109667320e-07
		,3.6654664070e-07
		,4.3804815190e-07
		,5.0750018770e-07
		,5.7593954790e-07
		,6.4397382750e-07
		,7.1232382570e-07
		,7.8298897220e-07
		,8.5812311930e-07
		,9.3904496390e-07
		,1.0263860360e-06
		,1.1200463210e-06
		,1.2190466210e-06
		,1.3215137690e-06
		,1.4263897370e-06
		,1.5350818000e-06
		,1.6512218210e-06
		,1.7768528960e-06
		,1.9129916010e-06
		,2.0597831540e-06
		,2.2163694830e-06
		,2.3816359890e-06
		,2.5549124330e-06
		,2.7360475490e-06
		,2.9253287030e-06
		,3.1229682980e-06
		,3.3289191190e-06
		,3.5433135920e-06
		,3.7663005370e-06
		,3.9972307380e-06
		,4.2343056300e-06
		,4.4751261230e-06
		,4.7179164920e-06
		,4.9624242660e-06
		,5.2095815000e-06
		,5.4606295190e-06
		,5.7168485430e-06
		,5.9796370660e-06
		,6.2504081970e-06
		,6.5303916280e-06
		,6.8208073320e-06
		,7.1234042410e-06
		,7.4398693280e-06
		,7.7714500460e-06
		,8.1190220340e-06
		,8.4831107470e-06
		,8.8639734320e-06
		,9.2618488790e-06
		,9.6771615470e-06
		,1.0110448540e-05
		,1.0562161460e-05
		,1.1032505870e-05
		,1.1521304400e-05
		,1.2027882120e-05
		,1.2551128310e-05
		,1.3089970890e-05
		,1.3644042510e-05
		,1.4213757890e-05
		,1.4799722030e-05
		,1.5402178950e-05
		,1.6020846650e-05
		,1.6655167100e-05
		,1.7304874360e-05
		,1.7970112180e-05
		,1.8651074770e-05
		,1.9347716060e-05
		,2.0059700080e-05
		,2.0786572790e-05
		,2.1527999490e-05
		,2.2283917920e-05
		,2.3054583250e-05
		,2.3840475930e-05
		,2.4642455550e-05
		,2.5461478780e-05
		,2.6298558550e-05
		,2.7154718790e-05
		,2.8030998670e-05
		,2.8928501300e-05
		,2.9848474450e-05
		,3.0792412950e-05
		,3.1762176200e-05
		,3.2760115540e-05
		,3.3789130340e-05
		,3.4852552610e-05
		,3.5955694390e-05
		,3.7105485300e-05
		,3.8310373000e-05
		,3.9580929980e-05
		,4.0930260550e-05
		,4.2374328720e-05
		,4.3932185250e-05
		,4.5626043950e-05
		,4.7481168330e-05
		,4.9525558750e-05
		,5.1789846510e-05
		,5.4308062300e-05
		,5.7111710290e-05
		,6.0232186700e-05
		,6.3697990360e-05
		,6.7532260800e-05
		,7.1750637910e-05
		,7.6360521180e-05
		,8.1356779860e-05
		,8.6721151480e-05
		,9.2429492550e-05
		,9.8449741200e-05
		,1.0477063510e-04
		,1.1141372990e-04
		,1.1842756570e-04
		,1.2584591200e-04
		,1.3367720050e-04
		,1.4191325390e-04
		,1.5053655480e-04
		,1.5952408420e-04
		,1.6884959430e-04
		,1.7848571880e-04
		,1.8840472710e-04
		,1.9857951200e-04
		////////////////////////////////
		,-2.0991150280e-17
		,5.9920006010e-07
		,1.1073353580e-06
		,1.5467789460e-06
		,1.9367764920e-06
		,2.2957034070e-06
		,2.6405207860e-06
		,2.9835759900e-06
		,3.3327692940e-06
		,3.6917809610e-06
		,4.0593008580e-06
		,4.4316318090e-06
		,4.8071526390e-06
		,5.1811655060e-06
		,5.5446442210e-06
		,5.8971849670e-06
		,6.2489801030e-06
		,6.6124058410e-06
		,6.9960702960e-06
		,7.4042538100e-06
		,7.8375582580e-06
		,8.2909724010e-06
		,8.7592141110e-06
		,9.2465411580e-06
		,9.7522328110e-06
		,1.0266491430e-05
		,1.0792032580e-05
		,1.1332453160e-05
		,1.1886121480e-05
		,1.2451231600e-05
		,1.3027302050e-05
		,1.3614393330e-05
		,1.4213463720e-05
		,1.4827026030e-05
		,1.5458300230e-05
		,1.6109809870e-05
		,1.6782833090e-05
		,1.7477539580e-05
		,1.8193485760e-05
		,1.8929242440e-05
		,1.9682032050e-05
		,2.0449517760e-05
		,2.1231114520e-05
		,2.2026514030e-05
		,2.2834099680e-05
		,2.3650576600e-05
		,2.4471840540e-05
		,2.5294688640e-05
		,2.6117543380e-05
		,2.6941441570e-05
		,2.7768899040e-05
		,2.8601837800e-05
		,2.9442204950e-05
		,3.0292093010e-05
		,3.1153198280e-05
		,3.2026611860e-05
		,3.2913032650e-05
		,3.3812941770e-05
		,3.4726503250e-05
		,3.5653371990e-05
		,3.6592603200e-05
		,3.7542644260e-05
		,3.8501313450e-05
		,3.9465734690e-05
		,4.0432280860e-05
		,4.1396595970e-05
		,4.2353779210e-05
		,4.3298961080e-05
		,4.4228554130e-05
		,4.5141619230e-05
		,4.6040061390e-05
		,4.6927118910e-05
		,4.7805064880e-05
		,4.8674268580e-05
		,4.9533460740e-05
		,5.0380797110e-05
		,5.1215397080e-05
		,5.2038235570e-05
		,5.2851665410e-05
		,5.3658368700e-05
		,5.4460797680e-05
		,5.5261291170e-05
		,5.6062183710e-05
		,5.6865737790e-05
		,5.7673840420e-05
		,5.8487898050e-05
		,5.9309016700e-05
		,6.0138223820e-05
		,6.0976556460e-05
		,6.1825070820e-05
		,6.2684895750e-05
		,6.3557338930e-05
		,6.4443908630e-05
		,6.5345828570e-05
		,6.6265370600e-05
		,6.7207264820e-05
		,6.8176587460e-05
		,6.9179562280e-05
		,7.0224109650e-05
		,7.1320237500e-05
		,7.2480414870e-05
		,7.3719920510e-05
		,7.5057126560e-05
		,7.6513658370e-05
		,7.8114361800e-05
		,7.9887023410e-05
		,8.1861787400e-05
		,8.4070280660e-05
		,8.6544514470e-05
		,8.9315349690e-05
		,9.2411335850e-05
		,9.5857603120e-05
		,9.9674696090e-05
		,1.0387801240e-04
		,1.0848168400e-04
		,1.1349095750e-04
		,1.1890555660e-04
		,1.2472300560e-04
		,1.3093751370e-04
		,1.3754071340e-04
		,1.4452654010e-04
		////////////////////////////////
		,-3.9686138280e-18
		,1.9480924930e-06
		,3.7202979600e-06
		,5.3522773100e-06
		,6.8506430970e-06
		,8.2046152150e-06
		,9.4562241180e-06
		,1.0659872140e-05
		,1.1843169420e-05
		,1.3016459610e-05
		,1.4178136950e-05
		,1.5321267070e-05
		,1.6443554640e-05
		,1.7545637940e-05
		,1.8623909840e-05
		,1.9681385540e-05
		,2.0732490900e-05
		,2.1782625110e-05
		,2.2826637250e-05
		,2.3855843840e-05
		,2.4859321830e-05
		,2.5855015060e-05
		,2.6867833470e-05
		,2.7906892920e-05
		,2.8971388260e-05
		,3.0050070510e-05
		,3.1107808030e-05
		,3.2104864530e-05
		,3.3068208340e-05
		,3.4031612670e-05
		,3.4999485860e-05
		,3.5961309730e-05
		,3.6897593330e-05
		,3.7821626380e-05
		,3.8749030090e-05
		,3.9683996930e-05
		,4.0628354740e-05
		,4.1585947940e-05
		,4.2558262270e-05
		,4.3545237140e-05
		,4.4548388770e-05
		,4.5569268990e-05
		,4.6607276330e-05
		,4.7657293620e-05
		,4.8706234970e-05
		,4.9736246470e-05
		,5.0739700820e-05
		,5.1723656600e-05
		,5.2700465410e-05
		,5.3680502070e-05
		,5.4669334230e-05
		,5.5667348970e-05
		,5.6671963410e-05
		,5.7678408520e-05
		,5.8680678700e-05
		,5.9673716060e-05
		,6.0650947350e-05
		,6.1608196130e-05
		,6.2546830070e-05
		,6.3469987360e-05
		,6.4378974330e-05
		,6.5273688940e-05
		,6.6155156520e-05
		,6.7025834180e-05
		,6.7887624370e-05
		,6.8741513740e-05
		,6.9588806950e-05
		,7.0431379040e-05
		,7.1270954320e-05
		,7.2109001140e-05
		,7.2946977310e-05
		,7.3786131650e-05
		,7.4627196670e-05
		,7.5470373080e-05
		,7.6315348970e-05
		,7.7161240700e-05
		,7.8007068920e-05
		,7.8851838010e-05
		,7.9693743320e-05
		,8.0530169060e-05
		,8.1358356760e-05
		,8.2176376980e-05
		,8.2983616280e-05
		,8.3780283060e-05
		,8.4566548130e-05
		,8.5341995690e-05
		,8.6105508690e-05
		,8.6855478100e-05
		,8.7590315350e-05
		,8.8309302230e-05
		,8.9012893050e-05
		,8.9702079420e-05
		,9.0377590600e-05
		,9.1039656950e-05
		,9.1688378690e-05
		,9.2324301130e-05
		,9.2948600290e-05
		,9.3562754320e-05
		,9.4168229880e-05
		,9.4766518440e-05
		,9.5359142780e-05
		,9.5947234780e-05
		,9.6534006150e-05
		,9.7123587410e-05
		,9.7720071000e-05
		,9.8328329760e-05
		,9.8954380560e-05
		,9.9605662250e-05
		,1.0029136150e-04
		,1.0102274410e-04
		,1.0181350110e-04
		,1.0268002860e-04
		,1.0364161840e-04
		,1.0472051250e-04
		,1.0594174050e-04
		,1.0733274170e-04
		,1.0892272160e-04
		,1.1074178100e-04
		,1.1281989050e-04
		,1.1518581550e-04
		,1.1786611630e-04
		////////////////////////////////
		,3.9160579630e-18
		,3.9011038730e-06
		,7.4968017080e-06
		,1.0818941250e-05
		,1.3914762440e-05
		,1.6821849840e-05
		,1.9546173700e-05
		,2.2061969610e-05
		,2.4347291900e-05
		,2.6376768640e-05
		,2.8220119690e-05
		,2.9959976440e-05
		,3.1631739580e-05
		,3.3248692440e-05
		,3.4818985810e-05
		,3.6354771170e-05
		,3.7858400170e-05
		,3.9309889550e-05
		,4.0714961550e-05
		,4.2100306510e-05
		,4.3476753060e-05
		,4.4846204450e-05
		,4.6207228280e-05
		,4.7556446950e-05
		,4.8889188600e-05
		,5.0201149520e-05
		,5.1491289570e-05
		,5.2761736530e-05
		,5.4013386360e-05
		,5.5244210450e-05
		,5.6450291770e-05
		,5.7615869330e-05
		,5.8719791580e-05
		,5.9783488600e-05
		,6.0831595420e-05
		,6.1868986700e-05
		,6.2894215850e-05
		,6.3908624130e-05
		,6.4905643740e-05
		,6.5864491780e-05
		,6.6805514900e-05
		,6.7743746630e-05
		,6.8680296380e-05
		,6.9613523010e-05
		,7.0540299610e-05
		,7.1458512280e-05
		,7.2366984880e-05
		,7.3263672450e-05
		,7.4149626610e-05
		,7.5027195410e-05
		,7.5897159450e-05
		,7.6759458230e-05
		,7.7614548040e-05
		,7.8463297170e-05
		,7.9306059150e-05
		,8.0142506320e-05
		,8.0972124930e-05
		,8.1794531620e-05
		,8.2608251200e-05
		,8.3410734000e-05
		,8.4202522010e-05
		,8.4985500890e-05
		,8.5759736940e-05
		,8.6523858930e-05
		,8.7275550340e-05
		,8.8012327130e-05
		,8.8732897120e-05
		,8.9437848960e-05
		,9.0129140740e-05
		,9.0809257010e-05
		,9.1479998430e-05
		,9.2142353820e-05
		,9.2796892210e-05
		,9.3443803030e-05
		,9.4082998320e-05
		,9.4714205320e-05
		,9.5336953430e-05
		,9.5950443360e-05
		,9.6553268260e-05
		,9.7143124120e-05
		,9.7717264690e-05
		,9.8273871600e-05
		,9.8812780740e-05
		,9.9335101620e-05
		,9.9842306320e-05
		,1.0033588440e-04
		,1.0081724720e-04
		,1.0128763160e-04
		,1.0174808030e-04
		,1.0219941340e-04
		,1.0264221130e-04
		,1.0307685220e-04
		,1.0350356010e-04
		,1.0392248270e-04
		,1.0433369170e-04
		,1.0473723610e-04
		,1.0513318560e-04
		,1.0552160550e-04
		,1.0590249150e-04
		,1.0627572000e-04
		,1.0664105330e-04
		,1.0699825000e-04
		,1.0734728020e-04
		,1.0768847160e-04
		,1.0802240960e-04
		,1.0834971410e-04
		,1.0867093270e-04
		,1.0898661440e-04
		,1.0929740450e-04
		,1.0960390510e-04
		,1.0990809580e-04
		,1.1021252540e-04
		,1.1051974400e-04
		,1.1083290230e-04
		,1.1115608150e-04
		,1.1149451380e-04
		,1.1185483080e-04
		,1.1224537470e-04
		,1.1267655510e-04
		,1.1316113840e-04
		,1.1371445770e-04
		////////////////////////////////
		,6.8923910220e-18
		,5.1926535670e-06
		,1.0093231960e-05
		,1.4722580860e-05
		,1.9102422180e-05
		,2.3254870970e-05
		,2.7200330230e-05
		,3.0955016910e-05
		,3.4528208560e-05
		,3.7917318700e-05
		,4.1099271130e-05
		,4.4039943520e-05
		,4.6748034630e-05
		,4.9265367220e-05
		,5.1618440900e-05
		,5.3820527600e-05
		,5.5885054730e-05
		,5.7815774570e-05
		,5.9600884520e-05
		,6.1262379310e-05
		,6.2856378130e-05
		,6.4413930210e-05
		,6.5943677960e-05
		,6.7446014250e-05
		,6.8918456650e-05
		,7.0356565930e-05
		,7.1756323810e-05
		,7.3116743000e-05
		,7.4432383200e-05
		,7.5689552380e-05
		,7.6863501690e-05
		,7.7954107910e-05
		,7.8999215490e-05
		,8.0021621180e-05
		,8.1025636940e-05
		,8.2004619310e-05
		,8.2941150970e-05
		,8.3828136410e-05
		,8.4683563390e-05
		,8.5518742320e-05
		,8.6336061190e-05
		,8.7135457180e-05
		,8.7915933070e-05
		,8.8676141890e-05
		,8.9414332380e-05
		,9.0121595140e-05
		,9.0774978830e-05
		,9.1393648690e-05
		,9.2001624810e-05
		,9.2602607750e-05
		,9.3195868070e-05
		,9.3780101160e-05
		,9.4354328860e-05
		,9.4918530050e-05
		,9.5472865940e-05
		,9.6017188980e-05
		,9.6551197700e-05
		,9.7074541960e-05
		,9.7586840470e-05
		,9.8087653060e-05
		,9.8576397810e-05
		,9.9052314900e-05
		,9.9515138500e-05
		,9.9965046360e-05
		,1.0040108090e-04
		,1.0082211440e-04
		,1.0122965190e-04
		,1.0162586180e-04
		,1.0201194770e-04
		,1.0238870720e-04
		,1.0275679680e-04
		,1.0311679850e-04
		,1.0346923770e-04
		,1.0381458940e-04
		,1.0415328930e-04
		,1.0448571140e-04
		,1.0481210230e-04
		,1.0513263200e-04
		,1.0544746430e-04
		,1.0575675950e-04
		,1.0606067500e-04
		,1.0635937130e-04
		,1.0665300800e-04
		,1.0694177190e-04
		,1.0722588550e-04
		,1.0750555850e-04
		,1.0778091710e-04
		,1.0805197020e-04
		,1.0831877910e-04
		,1.0858162000e-04
		,1.0884072190e-04
		,1.0909619070e-04
		,1.0934808930e-04
		,1.0959646610e-04
		,1.0984134970e-04
		,1.1008272470e-04
		,1.1032052920e-04
		,1.1055465880e-04
		,1.1078496580e-04
		,1.1101128630e-04
		,1.1123345950e-04
		,1.1145138080e-04
		,1.1166511820e-04
		,1.1187499370e-04
		,1.1208152770e-04
		,1.1228529620e-04
		,1.1248682040e-04
		,1.1268652130e-04
		,1.1288472740e-04
		,1.1308170200e-04
		,1.1327767070e-04
		,1.1347284470e-04
		,1.1366744380e-04
		,1.1386171860e-04
		,1.1405597340e-04
		,1.1425058300e-04
		,1.1444593730e-04
		,1.1464228010e-04
		,1.1484076910e-04
		,1.1504295920e-04
		,1.1525053560e-04
		////////////////////////////////
		,8.3022329980e-18
		,6.1928302420e-06
		,1.2049040420e-05
		,1.7591466500e-05
		,2.2841991640e-05
		,2.7821942830e-05
		,3.2550736300e-05
		,3.7043983770e-05
		,4.1311107570e-05
		,4.5351317360e-05
		,4.9149591150e-05
		,5.2687842170e-05
		,5.5977554700e-05
		,5.9056508630e-05
		,6.1957275090e-05
		,6.4699570430e-05
		,6.7294455360e-05
		,6.9748195410e-05
		,7.2064569070e-05
		,7.4246037690e-05
		,7.6294365480e-05
		,7.8211356780e-05
		,8.0001167630e-05
		,8.1672730590e-05
		,8.3237295880e-05
		,8.4704161480e-05
		,8.6079131480e-05
		,8.7364333920e-05
		,8.8557762020e-05
		,8.9653594060e-05
		,9.0650096820e-05
		,9.1562101740e-05
		,9.2411415800e-05
		,9.3213894030e-05
		,9.3979277260e-05
		,9.4713416570e-05
		,9.5419737430e-05
		,9.6099711600e-05
		,9.6754475620e-05
		,9.7385427020e-05
		,9.7989839340e-05
		,9.8560020730e-05
		,9.9089376640e-05
		,9.9578390390e-05
		,1.0003599930e-04
		,1.0047602250e-04
		,1.0090513840e-04
		,1.0132556450e-04
		,1.0173806650e-04
		,1.0214283710e-04
		,1.0253975000e-04
		,1.0292818520e-04
		,1.0330525220e-04
		,1.0366086880e-04
		,1.0399678970e-04
		,1.0432527440e-04
		,1.0464874170e-04
		,1.0496699940e-04
		,1.0527943290e-04
		,1.0558487930e-04
		,1.0588176120e-04
		,1.0617131050e-04
		,1.0645552630e-04
		,1.0673494250e-04
		,1.0700953720e-04
		,1.0727914170e-04
		,1.0754356820e-04
		,1.0780269560e-04
		,1.0805648480e-04
		,1.0830482170e-04
		,1.0854717950e-04
		,1.0878300880e-04
		,1.0901351160e-04
		,1.0924027680e-04
		,1.0946405250e-04
		,1.0968509100e-04
		,1.0990361540e-04
		,1.1011997760e-04
		,1.1033432500e-04
		,1.1054671820e-04
		,1.1075721370e-04
		,1.1096583150e-04
		,1.1117254160e-04
		,1.1137730990e-04
		,1.1158013380e-04
		,1.1178105750e-04
		,1.1198014760e-04
		,1.1217739650e-04
		,1.1237274050e-04
		,1.1256615670e-04
		,1.1275767460e-04
		,1.1294735010e-04
		,1.1313523810e-04
		,1.1332135560e-04
		,1.1350569500e-04
		,1.1368837270e-04
		,1.1386957870e-04
		,1.1404947220e-04
		,1.1422819570e-04
		,1.1440588570e-04
		,1.1458266080e-04
		,1.1475859740e-04
		,1.1493371950e-04
		,1.1510803680e-04
		,1.1528154330e-04
		,1.1545419960e-04
		,1.1562597660e-04
		,1.1579687380e-04
		,1.1596691760e-04
		,1.1613615520e-04
		,1.1630461980e-04
		,1.1647228440e-04
		,1.1663909390e-04
		,1.1680500820e-04
		,1.1696999790e-04
		,1.1713402980e-04
		,1.1729705690e-04
		,1.1745901390e-04
		,1.1761981010e-04
		,1.1777935490e-04
		,1.1793764890e-04
		////////////////////////////////
		,7.7800692940e-18
		,1.8615971010e-14
		,3.1804677180e-14
		,4.1223883640e-14
		,4.8031645030e-14
		,5.3014078790e-14
		,5.6758201340e-14
		,5.9611251560e-14
		,6.1880940490e-14
		,6.3730078780e-14
		,6.5306960920e-14
		,6.6661505760e-14
		,6.7882011180e-14
		,6.8979390400e-14
		,7.0037555130e-14
		,7.1033373510e-14
		,7.1946011220e-14
		,7.2892276270e-14
		,7.3772017660e-14
		,7.4613223370e-14
		,7.5424770190e-14
		,7.6242374100e-14
		,7.7070891240e-14
		,7.7836957590e-14
		,7.8554514940e-14
		,7.9327421640e-14
		,8.0020489510e-14
		,8.0710894350e-14
		,8.1437694000e-14
		,8.2135461340e-14
		,8.2795632900e-14
		,8.3456222190e-14
		,8.4107308100e-14
		,8.4806015340e-14
		,8.5464620410e-14
		,8.6159724720e-14
		,8.6795511240e-14
		,8.7473958530e-14
		,8.8142223620e-14
		,8.8826675790e-14
		,8.9514991980e-14
		,9.0204300270e-14
		,9.0863793020e-14
		,9.1596649760e-14
		,9.2275044830e-14
		,9.2997667170e-14
		,9.3708749690e-14
		,9.4403697350e-14
		,9.5141932380e-14
		,9.5858863140e-14
		,9.6592137610e-14
		,9.7311157020e-14
		,9.8052263950e-14
		,9.8795511760e-14
		,9.9559071730e-14
		,1.0030362490e-13
		,1.0108144000e-13
		,1.0181998830e-13
		,1.0263696560e-13
		,1.0337708040e-13
		,1.0425723960e-13
		,1.0505374810e-13
		,1.0590033210e-13
		,1.0676639280e-13
		,1.0761203690e-13
		,1.0851214270e-13
		,1.0942196070e-13
		,1.1043694250e-13
		,1.1146419510e-13
		,1.1255285420e-13
		,1.1374161210e-13
		,1.1504503710e-13
		,1.1655409020e-13
		,1.1812157330e-13
		,1.2008981720e-13
		,1.2236117700e-13
		,1.2512122990e-13
		,1.2849795810e-13
		,1.3260498440e-13
		,1.3783758680e-13
		,1.4453585040e-13
		,1.5311881170e-13
		,1.6430893640e-13
		,1.7897275500e-13
		,1.9784599620e-13
		,2.1960617610e-13
		,2.4703940340e-13
		,2.8248126420e-13
		,3.2847600100e-13
		,3.8834561940e-13
		,4.6667403760e-13
		,5.6945861910e-13
		,7.0503685590e-13
		,8.8453757080e-13
		,1.1229653460e-12
		,1.4376993040e-12
		,1.8233485230e-12
		,2.3251378600e-12
		,2.9786514150e-12
		,3.8305013820e-12
		,4.9417657190e-12
		,6.3897241300e-12
		,8.2753003630e-12
		,1.0738417530e-11
		,1.3959677580e-11
		,1.8175484380e-11
		,2.3696511410e-11
		,3.0931672970e-11
		,4.0419335030e-11
		,5.2868285940e-11
		,6.9212477450e-11
		,9.0682935940e-11
		,1.1890325410e-10
		,1.5601521960e-10
		,2.0484584940e-10
		,2.6909793020e-10
		,3.5369404650e-10
		,4.6515438550e-10
		,6.1208026880e-10
		,8.0584631110e-10
		,1.0615014210e-09
		////////////////////////////////
		,1.0286455040e-17
		,7.5157187600e-06
		,1.4675068040e-05
		,2.1491013000e-05
		,2.7974438840e-05
		,3.4133281300e-05
		,3.9971554100e-05
		,4.5488847690e-05
		,5.0682008740e-05
		,5.5550033810e-05
		,6.0098160600e-05
		,6.4336115970e-05
		,6.8272263340e-05
		,7.1907220210e-05
		,7.5227659970e-05
		,7.8220774410e-05
		,8.0917247120e-05
		,8.3367669150e-05
		,8.5607763740e-05
		,8.7661266760e-05
		,8.9546262780e-05
		,9.1277971120e-05
		,9.2869861100e-05
		,9.4334139660e-05
		,9.5681988210e-05
		,9.6923687290e-05
		,9.8068685380e-05
		,9.9125634000e-05
		,1.0010239160e-04
		,1.0100597150e-04
		,1.0184235990e-04
		,1.0261607650e-04
		,1.0332979050e-04
		,1.0398674530e-04
		,1.0459545520e-04
		,1.0516578060e-04
		,1.0570414340e-04
		,1.0621437050e-04
		,1.0669903200e-04
		,1.0716002050e-04
		,1.0759874200e-04
		,1.0801617010e-04
		,1.0841291250e-04
		,1.0878934970e-04
		,1.0914555800e-04
		,1.0948072120e-04
		,1.0979339260e-04
		,1.1008481880e-04
		,1.1035965360e-04
		,1.1062186070e-04
		,1.1087403900e-04
		,1.1111824840e-04
		,1.1135583100e-04
		,1.1158741780e-04
		,1.1181316110e-04
		,1.1203321960e-04
		,1.1224834200e-04
		,1.1245950880e-04
		,1.1266738020e-04
		,1.1287223110e-04
		,1.1307373690e-04
		,1.1327177250e-04
		,1.1346745030e-04
		,1.1366130370e-04
		,1.1385351930e-04
		,1.1404411200e-04
		,1.1423266990e-04
		,1.1441693180e-04
		,1.1459105930e-04
		,1.1475720060e-04
		,1.1492091950e-04
		,1.1508416390e-04
		,1.1524740700e-04
		,1.1541066490e-04
		,1.1557385410e-04
		,1.1573688470e-04
		,1.1589968170e-04
		,1.1606218470e-04
		,1.1622434190e-04
		,1.1638609410e-04
		,1.1654733040e-04
		,1.1670776030e-04
		,1.1686665210e-04
		,1.1702313440e-04
		,1.1717750260e-04
		,1.1733050600e-04
		,1.1748232270e-04
		,1.1763267180e-04
		,1.1778187460e-04
		,1.1793066960e-04
		,1.1807929290e-04
		,1.1822774130e-04
		,1.1837597450e-04
		,1.1852395740e-04
		,1.1867166400e-04
		,1.1881907820e-04
		,1.1896618790e-04
		,1.1911303650e-04
		,1.1925972130e-04
		,1.1940623080e-04
		,1.1955248700e-04
		,1.1969843400e-04
		,1.1984402560e-04
		,1.1998917290e-04
		,1.2013380760e-04
		,1.2027788340e-04
		,1.2042126180e-04
		,1.2056402780e-04
		,1.2070652880e-04
		,1.2084904060e-04
		,1.2099163040e-04
		,1.2113423410e-04
		,1.2127682270e-04
		,1.2141941370e-04
		,1.2156201630e-04
		,1.2170457540e-04
		,1.2184698810e-04
		,1.2198917240e-04
		,1.2213113330e-04
		,1.2227294450e-04
		,1.2241468220e-04
		////////////////////////////////
		,-2.0366081610e-18
		,8.0033727480e-06
		,1.5633137670e-05
		,2.2897092840e-05
		,2.9800257570e-05
		,3.6344937410e-05
		,4.2531748790e-05
		,4.8361125500e-05
		,5.3833913300e-05
		,5.8950630430e-05
		,6.3707628600e-05
		,6.8089378030e-05
		,7.2079724220e-05
		,7.5702276290e-05
		,7.9000053030e-05
		,8.2005657720e-05
		,8.4743828160e-05
		,8.7235852560e-05
		,8.9501258320e-05
		,9.1558385670e-05
		,9.3424497380e-05
		,9.5115534660e-05
		,9.6645403590e-05
		,9.8025554900e-05
		,9.9269044600e-05
		,1.0039355680e-04
		,1.0141404090e-04
		,1.0233914640e-04
		,1.0317577000e-04
		,1.0393928250e-04
		,1.0464590580e-04
		,1.0530519560e-04
		,1.0592283320e-04
		,1.0650256810e-04
		,1.0704643640e-04
		,1.0755360370e-04
		,1.0801802700e-04
		,1.0843637350e-04
		,1.0882212130e-04
		,1.0918776820e-04
		,1.0953882030e-04
		,1.0987789970e-04
		,1.1020656370e-04
		,1.1052589410e-04
		,1.1083671370e-04
		,1.1113967830e-04
		,1.1143531880e-04
		,1.1172405670e-04
		,1.1200619750e-04
		,1.1228189990e-04
		,1.1255113060e-04
		,1.1281371650e-04
		,1.1306969500e-04
		,1.1331962150e-04
		,1.1356423780e-04
		,1.1380407660e-04
		,1.1403943050e-04
		,1.1427044690e-04
		,1.1449721600e-04
		,1.1471985410e-04
		,1.1493856370e-04
		,1.1515361250e-04
		,1.1536526790e-04
		,1.1557375890e-04
		,1.1577926610e-04
		,1.1598191280e-04
		,1.1618174300e-04
		,1.1637871260e-04
		,1.1657284070e-04
		,1.1676449990e-04
		,1.1695419470e-04
		,1.1714189770e-04
		,1.1732686180e-04
		,1.1750961670e-04
		,1.1768921730e-04
		,1.1786047060e-04
		,1.1802454260e-04
		,1.1818719740e-04
		,1.1834970920e-04
		,1.1851205470e-04
		,1.1867401100e-04
		,1.1883525900e-04
		,1.1899536300e-04
		,1.1915426220e-04
		,1.1931254870e-04
		,1.1947061940e-04
		,1.1962847990e-04
		,1.1978576870e-04
		,1.1994176480e-04
		,1.2009615870e-04
		,1.2024934320e-04
		,1.2040164020e-04
		,1.2055315190e-04
		,1.2070386210e-04
		,1.2085367270e-04
		,1.2100238770e-04
		,1.2114967710e-04
		,1.2129512160e-04
		,1.2143848140e-04
		,1.2157994060e-04
		,1.2171985370e-04
		,1.2185846360e-04
		,1.2199626760e-04
		,1.2213376970e-04
		,1.2227120790e-04
		,1.2240865100e-04
		,1.2254607890e-04
		,1.2268345660e-04
		,1.2282073920e-04
		,1.2295789660e-04
		,1.2309492520e-04
		,1.2323171370e-04
		,1.2336805070e-04
		,1.2350391870e-04
		,1.2363959480e-04
		,1.2377522160e-04
		,1.2391078740e-04
		,1.2404626760e-04
		,1.2418168170e-04
		,1.2431706100e-04
		,1.2445239760e-04
		////////////////////////////////
		,3.3000575760e-17
		,8.4156582960e-06
		,1.6437937570e-05
		,2.4070359580e-05
		,3.1315901300e-05
		,3.8176899930e-05
		,4.4653783290e-05
		,5.0742884700e-05
		,5.6432882340e-05
		,6.1698046560e-05
		,6.6519343140e-05
		,7.0921890020e-05
		,7.4940449500e-05
		,7.8601541680e-05
		,8.1928605890e-05
		,8.4944421450e-05
		,8.7671481380e-05
		,9.0131998380e-05
		,9.2347858890e-05
		,9.4340511240e-05
		,9.6130762130e-05
		,9.7738458870e-05
		,9.9181952780e-05
		,1.0047691030e-04
		,1.0163393680e-04
		,1.0266357010e-04
		,1.0359091490e-04
		,1.0443831400e-04
		,1.0521751930e-04
		,1.0593414680e-04
		,1.0658505270e-04
		,1.0715687750e-04
		,1.0766350850e-04
		,1.0812876650e-04
		,1.0856443990e-04
		,1.0897785620e-04
		,1.0937354430e-04
		,1.0975431740e-04
		,1.1012212430e-04
		,1.1047844820e-04
		,1.1082448330e-04
		,1.1116122280e-04
		,1.1148950880e-04
		,1.1181006290e-04
		,1.1212350820e-04
		,1.1243038350e-04
		,1.1273115420e-04
		,1.1302621810e-04
		,1.1331590680e-04
		,1.1360047970e-04
		,1.1388010650e-04
		,1.1415483340e-04
		,1.1442454860e-04
		,1.1468903430e-04
		,1.1494824090e-04
		,1.1520255590e-04
		,1.1545261020e-04
		,1.1569893800e-04
		,1.1594188820e-04
		,1.1618167710e-04
		,1.1641844450e-04
		,1.1665228840e-04
		,1.1688328240e-04
		,1.1711148420e-04
		,1.1733693970e-04
		,1.1755968390e-04
		,1.1777973860e-04
		,1.1799710810e-04
		,1.1821176840e-04
		,1.1842364740e-04
		,1.1863257900e-04
		,1.1883818810e-04
		,1.1903962150e-04
		,1.1923545130e-04
		,1.1942537330e-04
		,1.1961120320e-04
		,1.1979456660e-04
		,1.1997624560e-04
		,1.2015657960e-04
		,1.2033564410e-04
		,1.2051311010e-04
		,1.2068727890e-04
		,1.2085301770e-04
		,1.2100980260e-04
		,1.2116346610e-04
		,1.2131684530e-04
		,1.2147045960e-04
		,1.2162427190e-04
		,1.2177816940e-04
		,1.2193204620e-04
		,1.2208580780e-04
		,1.2223934760e-04
		,1.2239248570e-04
		,1.2254490440e-04
		,1.2269635580e-04
		,1.2284683840e-04
		,1.2299633240e-04
		,1.2314498160e-04
		,1.2329307130e-04
		,1.2344075260e-04
		,1.2358807660e-04
		,1.2373505710e-04
		,1.2388169520e-04
		,1.2402798710e-04
		,1.2417392760e-04
		,1.2431951130e-04
		,1.2446473380e-04
		,1.2460959290e-04
		,1.2475409060e-04
		,1.2489823570e-04
		,1.2504204530e-04
		,1.2518554350e-04
		,1.2532875780e-04
		,1.2547170280e-04
		,1.2561434420e-04
		,1.2575663520e-04
		,1.2589865970e-04
		,1.2604043250e-04
		,1.2618181890e-04
		,1.2632282180e-04
		,1.2646362100e-04
		////////////////////////////////
		,1.9840522990e-18
		,1.9716653150e-09
		,3.6527462110e-09
		,5.1395691930e-09
		,6.5074322520e-09
		,7.8158227260e-09
		,9.1106805550e-09
		,1.0425219890e-08
		,1.1781457630e-08
		,1.3198005630e-08
		,1.4699295560e-08
		,1.6312731350e-08
		,1.8062073590e-08
		,1.9963838710e-08
		,2.2022830160e-08
		,2.4225223860e-08
		,2.6537618490e-08
		,2.8929288490e-08
		,3.1401352840e-08
		,3.3977911580e-08
		,3.6680263210e-08
		,3.9522289770e-08
		,4.2522463200e-08
		,4.5712694600e-08
		,4.9130839950e-08
		,5.2811262630e-08
		,5.6785027790e-08
		,6.1083609850e-08
		,6.5740030260e-08
		,7.0785306490e-08
		,7.6245702990e-08
		,8.2141363140e-08
		,8.8486028260e-08
		,9.5289684340e-08
		,1.0256721690e-07
		,1.1035189690e-07
		,1.1869759420e-07
		,1.2766628130e-07
		,1.3731913190e-07
		,1.4771616730e-07
		,1.5892087500e-07
		,1.7100679530e-07
		,1.8405941210e-07
		,1.9817253310e-07
		,2.1344556630e-07
		,2.2998268130e-07
		,2.4789131940e-07
		,2.6727769040e-07
		,2.8823757110e-07
		,3.1084112230e-07
		,3.3512036950e-07
		,3.6109042290e-07
		,3.8881883540e-07
		,4.1846867540e-07
		,4.5025731690e-07
		,4.8440087210e-07
		,5.2109283280e-07
		,5.6051200710e-07
		,6.0284828510e-07
		,6.4831562260e-07
		,6.9711011620e-07
		,7.4934576650e-07
		,8.0502869410e-07
		,8.6416296310e-07
		,9.2707153510e-07
		,9.9468852530e-07
		,1.0682959000e-06
		,1.1498309420e-06
		,1.2418467370e-06
		,1.3476575070e-06
		,1.4711140990e-06
		,1.6167149100e-06
		,1.7900971750e-06
		,1.9977155840e-06
		,2.2466525270e-06
		,2.5481335400e-06
		,2.9143958190e-06
		,3.3601216200e-06
		,3.9028380660e-06
		,4.5608330010e-06
		,5.3586576910e-06
		,6.3257045280e-06
		,7.4945727430e-06
		,8.9016996870e-06
		,1.0582850540e-05
		,1.2571684350e-05
		,1.4896968420e-05
		,1.7600257050e-05
		,2.0749138800e-05
		,2.4397134040e-05
		,2.8591002110e-05
		,3.3354298860e-05
		,3.8634289010e-05
		,4.4169576630e-05
		,5.0066468350e-05
		,5.6086808310e-05
		,6.2613943730e-05
		,6.9775487560e-05
		,7.7638491580e-05
		,8.6227536110e-05
		,9.5557024310e-05
		,1.0563508540e-04
		,1.1646427090e-04
		,1.2804153840e-04
		,1.4035818560e-04
		,1.5339987840e-04
		,1.6714691310e-04
		,1.8157452280e-04
		,1.9665319420e-04
		,2.1234887850e-04
		,2.2862353530e-04
		,2.4543462540e-04
		,2.6273507770e-04
		,2.8047475530e-04
		,2.9852910320e-04
		,3.1687617990e-04
		,3.3532721560e-04
		,3.5387174370e-04
		,3.7260913700e-04
		,3.9149493760e-04
		,4.1048265710e-04
		////////////////////////////////
		,1.6185377110e-18
		,7.8188438870e-09
		,1.4546180460e-08
		,2.0495991230e-08
		,2.5929633660e-08
		,3.1026947070e-08
		,3.5861017940e-08
		,4.0514243530e-08
		,4.5114115360e-08
		,4.9770637900e-08
		,5.4571242500e-08
		,5.9597064460e-08
		,6.4929170300e-08
		,7.0637839310e-08
		,7.6792624530e-08
		,8.3470850380e-08
		,9.0746766000e-08
		,9.8687161070e-08
		,1.0735687050e-07
		,1.1682213200e-07
		,1.2714345510e-07
		,1.3836360320e-07
		,1.5050524910e-07
		,1.6359703330e-07
		,1.7772262340e-07
		,1.9301785140e-07
		,2.0962443320e-07
		,2.2766190150e-07
		,2.4721719130e-07
		,2.6834592220e-07
		,2.9109551600e-07
		,3.1553729480e-07
		,3.4175296450e-07
		,3.6978294420e-07
		,3.9960231980e-07
		,4.3119639410e-07
		,4.6470371710e-07
		,5.0037862270e-07
		,5.3841379720e-07
		,5.7885192860e-07
		,6.2157679920e-07
		,6.6625836000e-07
		,7.1228392210e-07
		,7.5889009780e-07
		,8.0560201430e-07
		,8.5259103530e-07
		,9.0054142290e-07
		,9.5027230250e-07
		,1.0024953960e-06
		,1.0577603290e-06
		,1.1164870010e-06
		,1.1790107390e-06
		,1.2456097370e-06
		,1.3165139710e-06
		,1.3919283350e-06
		,1.4720917710e-06
		,1.5573343460e-06
		,1.6480746050e-06
		,1.7447879350e-06
		,1.8479865280e-06
		,1.9582138490e-06
		,2.0760493410e-06
		,2.2021190320e-06
		,2.3371078480e-06
		,2.4817885190e-06
		,2.6370337700e-06
		,2.8038462810e-06
		,2.9833929500e-06
		,3.1770519460e-06
		,3.3864810780e-06
		,3.6137222840e-06
		,3.8613146850e-06
		,4.1325735020e-06
		,4.4318067970e-06
		,4.7645383320e-06
		,5.1379369010e-06
		,5.5609426500e-06
		,6.0444942270e-06
		,6.6017558800e-06
		,7.2458954190e-06
		,7.9985004970e-06
		,8.8855424960e-06
		,9.9368892690e-06
		,1.1185613340e-05
		,1.2667260550e-05
		,1.4410664700e-05
		,1.6451223200e-05
		,1.8808514210e-05
		,2.1452992400e-05
		,2.4348952080e-05
		,2.7533679500e-05
		,3.0946588440e-05
		,3.4695273690e-05
		,3.8893905140e-05
		,4.3603497140e-05
		,4.8862685630e-05
		,5.4701062490e-05
		,6.1143325430e-05
		,6.8210409840e-05
		,7.5917147210e-05
		,8.4277613890e-05
		,9.3303747330e-05
		,1.0300094930e-04
		,1.1337016560e-04
		,1.2440778260e-04
		,1.3610560030e-04
		,1.4845086340e-04
		,1.6142631460e-04
		,1.7501015460e-04
		,1.8917594820e-04
		,2.0389147600e-04
		,2.1912035840e-04
		,2.3481481540e-04
		,2.5091237100e-04
		,2.6739064900e-04
		,2.8422795630e-04
		,3.0139514510e-04
		,3.1885729260e-04
		,3.3657468400e-04
		,3.5421655930e-04
		,3.7189377010e-04
		////////////////////////////////
		,3.7594088580e-18
		,3.0143922960e-08
		,5.5972246960e-08
		,7.8950673260e-08
		,1.0012867340e-07
		,1.2034381280e-07
		,1.4038984970e-07
		,1.6093281420e-07
		,1.8239130210e-07
		,2.0502431530e-07
		,2.2862948550e-07
		,2.5237986260e-07
		,2.7635024190e-07
		,3.0145205200e-07
		,3.2856846560e-07
		,3.5833984390e-07
		,3.9117258380e-07
		,4.2720314640e-07
		,4.6618040350e-07
		,5.0741663960e-07
		,5.5010738170e-07
		,5.9381656750e-07
		,6.3849778340e-07
		,6.8419446010e-07
		,7.3101808070e-07
		,7.7936252880e-07
		,8.2993222950e-07
		,8.8351288030e-07
		,9.4080448760e-07
		,1.0023853660e-06
		,1.0687134530e-06
		,1.1401314870e-06
		,1.2168724860e-06
		,1.2990875200e-06
		,1.3869125920e-06
		,1.4805029990e-06
		,1.5799999020e-06
		,1.6855654510e-06
		,1.7975622460e-06
		,1.9167121050e-06
		,2.0438276460e-06
		,2.1795603970e-06
		,2.3243816370e-06
		,2.4786301460e-06
		,2.6426213620e-06
		,2.8168135750e-06
		,3.0018667160e-06
		,3.1985149460e-06
		,3.4074193480e-06
		,3.6290749280e-06
		,3.8637411660e-06
		,4.1114371070e-06
		,4.3720470010e-06
		,4.6454021370e-06
		,4.9312419650e-06
		,5.2293305320e-06
		,5.5398332820e-06
		,5.8634926480e-06
		,6.2014061230e-06
		,6.5547508130e-06
		,6.9246290810e-06
		,7.3118949130e-06
		,7.7170114370e-06
		,8.1399498840e-06
		,8.5800247020e-06
		,9.0356121380e-06
		,9.5038190150e-06
		,9.9803982680e-06
		,1.0460446670e-05
		,1.0940166320e-05
		,1.1418692130e-05
		,1.1897898940e-05
		,1.2380722900e-05
		,1.2869942010e-05
		,1.3368402800e-05
		,1.3880065680e-05
		,1.4410410040e-05
		,1.4965819560e-05
		,1.5553195190e-05
		,1.6179917970e-05
		,1.6854367800e-05
		,1.7586210460e-05
		,1.8387010820e-05
		,1.9270908640e-05
		,2.0255194640e-05
		,2.1360567010e-05
		,2.2612661920e-05
		,2.4040807980e-05
		,2.5677897040e-05
		,2.7559666700e-05
		,2.9723226130e-05
		,3.2205069760e-05
		,3.5042035200e-05
		,3.8275577960e-05
		,4.1941916640e-05
		,4.6074427600e-05
		,5.0703086180e-05
		,5.5854182600e-05
		,6.1547694990e-05
		,6.7803692610e-05
		,7.4639097250e-05
		,8.2064751710e-05
		,9.0086985140e-05
		,9.8707223020e-05
		,1.0792172850e-04
		,1.1772205400e-04
		,1.2809271970e-04
		,1.3901674280e-04
		,1.5048682310e-04
		,1.6248385500e-04
		,1.7498305490e-04
		,1.8796948650e-04
		,2.0141659800e-04
		,2.1529711090e-04
		,2.2959187060e-04
		,2.4427586490e-04
		,2.5931703880e-04
		,2.7467675550e-04
		,2.9030961250e-04
		,3.0616787570e-04
		,3.2209214760e-04
		////////////////////////////////
		,-1.7127138930e-17
		,1.4365528400e-07
		,2.6497255940e-07
		,3.7058308400e-07
		,4.6573477210e-07
		,5.5453017980e-07
		,6.4031506130e-07
		,7.2570583200e-07
		,8.1222079200e-07
		,9.0048048760e-07
		,9.9064596280e-07
		,1.0834818410e-06
		,1.1806377230e-06
		,1.2840161740e-06
		,1.3954914070e-06
		,1.5163933970e-06
		,1.6467744560e-06
		,1.7842738430e-06
		,1.9269575280e-06
		,2.0768960220e-06
		,2.2348196810e-06
		,2.4012265850e-06
		,2.5784338320e-06
		,2.7691304430e-06
		,2.9751699360e-06
		,3.1979883150e-06
		,3.4390922690e-06
		,3.6990422680e-06
		,3.9765866860e-06
		,4.2687183490e-06
		,4.5717505720e-06
		,4.8829208080e-06
		,5.2016961710e-06
		,5.5296195470e-06
		,5.8686750960e-06
		,6.2200667990e-06
		,6.5842004400e-06
		,6.9609049590e-06
		,7.3490463270e-06
		,7.7459805170e-06
		,8.1481277080e-06
		,8.5528470450e-06
		,8.9596369980e-06
		,9.3693007670e-06
		,9.7834338920e-06
		,1.0204464240e-05
		,1.0635028710e-05
		,1.1077836940e-05
		,1.1535363050e-05
		,1.2009706050e-05
		,1.2502681840e-05
		,1.3015958400e-05
		,1.3551064580e-05
		,1.4109248860e-05
		,1.4691337720e-05
		,1.5297622180e-05
		,1.5927715970e-05
		,1.6580436900e-05
		,1.7253999650e-05
		,1.7946850330e-05
		,1.8658656080e-05
		,1.9390269910e-05
		,2.0142762740e-05
		,2.0916618900e-05
		,2.1711563350e-05
		,2.2527138860e-05
		,2.3363431580e-05
		,2.4221133270e-05
		,2.5101216780e-05
		,2.6004520460e-05
		,2.6931603220e-05
		,2.7882886900e-05
		,2.8858833020e-05
		,2.9859937890e-05
		,3.0886515300e-05
		,3.1938759740e-05
		,3.3016637330e-05
		,3.4119927680e-05
		,3.5248370950e-05
		,3.6401880480e-05
		,3.7580830820e-05
		,3.8786355640e-05
		,4.0020514770e-05
		,4.1286283950e-05
		,4.2587473370e-05
		,4.3928526550e-05
		,4.5314185330e-05
		,4.6751820030e-05
		,4.8250679130e-05
		,4.9821690240e-05
		,5.1478350210e-05
		,5.3237326030e-05
		,5.5118969350e-05
		,5.7147720290e-05
		,5.9352322440e-05
		,6.1765753000e-05
		,6.4424664470e-05
		,6.7368477840e-05
		,7.0637931230e-05
		,7.4273256250e-05
		,7.8312128970e-05
		,8.2787634320e-05
		,8.7729502090e-05
		,9.3156474420e-05
		,9.9080377860e-05
		,1.0552393960e-04
		,1.1248362620e-04
		,1.1995990930e-04
		,1.2794645190e-04
		,1.3643765490e-04
		,1.4541551010e-04
		,1.5483933430e-04
		,1.6465721750e-04
		,1.7483166630e-04
		,1.8526126230e-04
		,1.9595058250e-04
		,2.0693482740e-04
		,2.1835141700e-04
		,2.3028737320e-04
		,2.4276702980e-04
		,2.5578111290e-04
		////////////////////////////////
		,1.0338671410e-17
		,6.9358890340e-07
		,1.2945397600e-06
		,1.8276831160e-06
		,2.3111570160e-06
		,2.7593805940e-06
		,3.1863063420e-06
		,3.6079115170e-06
		,4.0381933960e-06
		,4.4866204710e-06
		,4.9595581460e-06
		,5.4576773920e-06
		,5.9691291410e-06
		,6.4735195820e-06
		,6.9574547030e-06
		,7.4252936710e-06
		,7.8896840260e-06
		,8.3634278600e-06
		,8.8575909340e-06
		,9.3801215810e-06
		,9.9348628940e-06
		,1.0519022070e-05
		,1.1121421260e-05
		,1.1739970770e-05
		,1.2376750500e-05
		,1.3019542970e-05
		,1.3669983560e-05
		,1.4339289820e-05
		,1.5031698910e-05
		,1.5750257530e-05
		,1.6497099900e-05
		,1.7272982500e-05
		,1.8078308040e-05
		,1.8913293910e-05
		,1.9777333260e-05
		,2.0668899150e-05
		,2.1585652880e-05
		,2.2524501980e-05
		,2.3482045350e-05
		,2.4455319570e-05
		,2.5442387410e-05
		,2.6443979900e-05
		,2.7463608860e-05
		,2.8504707080e-05
		,2.9568630570e-05
		,3.0654393640e-05
		,3.1759573720e-05
		,3.2882048490e-05
		,3.4020283840e-05
		,3.5174280640e-05
		,3.6346311610e-05
		,3.7536884090e-05
		,3.8745230100e-05
		,3.9970503020e-05
		,4.1211477680e-05
		,4.2466191150e-05
		,4.3732438170e-05
		,4.5008762260e-05
		,4.6295143900e-05
		,4.7592994120e-05
		,4.8904666290e-05
		,5.0232851570e-05
		,5.1580067000e-05
		,5.2948258080e-05
		,5.4338454350e-05
		,5.5750428180e-05
		,5.7182329030e-05
		,5.8630346020e-05
		,6.0088703830e-05
		,6.1550665080e-05
		,6.3011272020e-05
		,6.4469296580e-05
		,6.5925090240e-05
		,6.7378117460e-05
		,6.8825764570e-05
		,7.0263107310e-05
		,7.1683621970e-05
		,7.3080966720e-05
		,7.4451185270e-05
		,7.5793683710e-05
		,7.7110476270e-05
		,7.8404736460e-05
		,7.9679800720e-05
		,8.0939204370e-05
		,8.2186899490e-05
		,8.3426876670e-05
		,8.4662443510e-05
		,8.5895985060e-05
		,8.7129422500e-05
		,8.8364936220e-05
		,8.9605540240e-05
		,9.0855281400e-05
		,9.2118739830e-05
		,9.3399912380e-05
		,9.4706868120e-05
		,9.6048760280e-05
		,9.7434295980e-05
		,9.8873057540e-05
		,1.0037618510e-04
		,1.0195696850e-04
		,1.0363143020e-04
		,1.0541884940e-04
		,1.0734219270e-04
		,1.0942838890e-04
		,1.1170836270e-04
		,1.1421676920e-04
		,1.1699137880e-04
		,1.2007209690e-04
		,1.2349967920e-04
		,1.2731425100e-04
		,1.3155378900e-04
		,1.3625272860e-04
		,1.4144083860e-04
		,1.4714245270e-04
		,1.5337607240e-04
		,1.6015430120e-04
		,1.6748508990e-04
		,1.7536951120e-04
		,1.8380420660e-04
		,1.9278158920e-04
		,2.0230193830e-04
		////////////////////////////////
		,9.3972490340e-19
		,2.3363892700e-06
		,4.4954465050e-06
		,6.5129598050e-06
		,8.4078460370e-06
		,1.0167801720e-05
		,1.1800372820e-05
		,1.3382132890e-05
		,1.4961239790e-05
		,1.6553723860e-05
		,1.8153807890e-05
		,1.9743871720e-05
		,2.1312770520e-05
		,2.2853190920e-05
		,2.4352513920e-05
		,2.5822663510e-05
		,2.7293207610e-05
		,2.8773131580e-05
		,3.0250641840e-05
		,3.1700482750e-05
		,3.3107951610e-05
		,3.4513508820e-05
		,3.5956993740e-05
		,3.7453881940e-05
		,3.9005489760e-05
		,4.0596715770e-05
		,4.2172424990e-05
		,4.3656457070e-05
		,4.5076690800e-05
		,4.6488665680e-05
		,4.7905780340e-05
		,4.9309316700e-05
		,5.0661086930e-05
		,5.1992934350e-05
		,5.3332177600e-05
		,5.4685036010e-05
		,5.6056115680e-05
		,5.7454035970e-05
		,5.8883517770e-05
		,6.0345528930e-05
		,6.1842772500e-05
		,6.3378696150e-05
		,6.4952936040e-05
		,6.6556765000e-05
		,6.8168300920e-05
		,6.9755135800e-05
		,7.1294024260e-05
		,7.2784511210e-05
		,7.4240759330e-05
		,7.5679099540e-05
		,7.7111924100e-05
		,7.8546276280e-05
		,7.9984633580e-05
		,8.1425391130e-05
		,8.2869332570e-05
		,8.4322035500e-05
		,8.5783905640e-05
		,8.7250439780e-05
		,8.8717539790e-05
		,9.0184760950e-05
		,9.1652509670e-05
		,9.3118548460e-05
		,9.4578400710e-05
		,9.6028942200e-05
		,9.7470296480e-05
		,9.8903510920e-05
		,1.0032876860e-04
		,1.0174663820e-04
		,1.0315921300e-04
		,1.0456917380e-04
		,1.0597898590e-04
		,1.0739129190e-04
		,1.0880902770e-04
		,1.1023472040e-04
		,1.1166981830e-04
		,1.1311545450e-04
		,1.1457424600e-04
		,1.1604871250e-04
		,1.1753995400e-04
		,1.1904784410e-04
		,1.2057112550e-04
		,1.2210727420e-04
		,1.2365241850e-04
		,1.2520174400e-04
		,1.2675066650e-04
		,1.2829630270e-04
		,1.2983791570e-04
		,1.3137565040e-04
		,1.3290909920e-04
		,1.3443647560e-04
		,1.3595449470e-04
		,1.3745911090e-04
		,1.3894708770e-04
		,1.4041736070e-04
		,1.4187080940e-04
		,1.4330872890e-04
		,1.4473168260e-04
		,1.4613971220e-04
		,1.4753340760e-04
		,1.4891360150e-04
		,1.5027959910e-04
		,1.5163800820e-04
		,1.5299621040e-04
		,1.5436021150e-04
		,1.5573702290e-04
		,1.5713497330e-04
		,1.5856381210e-04
		,1.6003506220e-04
		,1.6156250230e-04
		,1.6316253610e-04
		,1.6485450020e-04
		,1.6666095130e-04
		,1.6860782780e-04
		,1.7072448970e-04
		,1.7304339210e-04
		,1.7559948280e-04
		,1.7842917050e-04
		,1.8156923180e-04
		,1.8505542380e-04
		,1.8892112750e-04
		,1.9319610110e-04
		////////////////////////////////
		,-8.8247361900e-18
		,4.7832489540e-06
		,9.2364322910e-06
		,1.3397054920e-05
		,1.7329561280e-05
		,2.1079828950e-05
		,2.4641289100e-05
		,2.7984325970e-05
		,3.1077442630e-05
		,3.3848991710e-05
		,3.6394588760e-05
		,3.8841469890e-05
		,4.1239085680e-05
		,4.3601049780e-05
		,4.5930052720e-05
		,4.8234233020e-05
		,5.0510423830e-05
		,5.2723529560e-05
		,5.4878959810e-05
		,5.7013275210e-05
		,5.9139398600e-05
		,6.1256443070e-05
		,6.3358718460e-05
		,6.5438831120e-05
		,6.7489556040e-05
		,6.9506730570e-05
		,7.1492781030e-05
		,7.3454074970e-05
		,7.5393281130e-05
		,7.7306541050e-05
		,7.9181543100e-05
		,8.0982869270e-05
		,8.2694821390e-05
		,8.4348452750e-05
		,8.5985121450e-05
		,8.7624073330e-05
		,8.9263972600e-05
		,9.0895094020e-05
		,9.2474401760e-05
		,9.4000439440e-05
		,9.5534484060e-05
		,9.7087821510e-05
		,9.8660269150e-05
		,1.0024910920e-04
		,1.0184873460e-04
		,1.0345129320e-04
		,1.0505082780e-04
		,1.0664592420e-04
		,1.0823492510e-04
		,1.0981970970e-04
		,1.1140637800e-04
		,1.1299702060e-04
		,1.1459126580e-04
		,1.1618916950e-04
		,1.1779156380e-04
		,1.1939850450e-04
		,1.2100813590e-04
		,1.2261469920e-04
		,1.2420877410e-04
		,1.2579103200e-04
		,1.2737022330e-04
		,1.2894996950e-04
		,1.3053024430e-04
		,1.3210951980e-04
		,1.3368536630e-04
		,1.3525462300e-04
		,1.3681355360e-04
		,1.3835874850e-04
		,1.3988874810e-04
		,1.4140512560e-04
		,1.4291141050e-04
		,1.4441153190e-04
		,1.4590974600e-04
		,1.4740975250e-04
		,1.4891365950e-04
		,1.5042233230e-04
		,1.5193615000e-04
		,1.5345505680e-04
		,1.5497820340e-04
		,1.5650357270e-04
		,1.5802838110e-04
		,1.5955118730e-04
		,1.6107052580e-04
		,1.6258228430e-04
		,1.6407938000e-04
		,1.6555316040e-04
		,1.6699726680e-04
		,1.6841080000e-04
		,1.6979705540e-04
		,1.7116087520e-04
		,1.7250722710e-04
		,1.7384082620e-04
		,1.7516580700e-04
		,1.7648536190e-04
		,1.7780177610e-04
		,1.7911658570e-04
		,1.8043069220e-04
		,1.8174448110e-04
		,1.8305792460e-04
		,1.8437062680e-04
		,1.8568181610e-04
		,1.8699033530e-04
		,1.8829469050e-04
		,1.8959319680e-04
		,1.9088412590e-04
		,1.9216557550e-04
		,1.9343436250e-04
		,1.9468328420e-04
		,1.9591077060e-04
		,1.9711997210e-04
		,1.9831184470e-04
		,1.9948794070e-04
		,2.0065058620e-04
		,2.0180280140e-04
		,2.0294902730e-04
		,2.0409604950e-04
		,2.0525337830e-04
		,2.0643289300e-04
		,2.0764906410e-04
		,2.0891928520e-04
		,2.1026447000e-04
		////////////////////////////////
		,1.3680519060e-17
		,6.3582056860e-06
		,1.2433639450e-05
		,1.8263103290e-05
		,2.3881004190e-05
		,2.9315961140e-05
		,3.4588165790e-05
		,3.9707143120e-05
		,4.4666088870e-05
		,4.9424348650e-05
		,5.3896201780e-05
		,5.8047042250e-05
		,6.1939478150e-05
		,6.5619038260e-05
		,6.9096723510e-05
		,7.2384600950e-05
		,7.5495399690e-05
		,7.8413360940e-05
		,8.1141568880e-05
		,8.3764272830e-05
		,8.6354373250e-05
		,8.8938617420e-05
		,9.1522651790e-05
		,9.4105083750e-05
		,9.6681987850e-05
		,9.9247447240e-05
		,1.0179160600e-04
		,1.0430688540e-04
		,1.0678401130e-04
		,1.0919800970e-04
		,1.1150520910e-04
		,1.1368061620e-04
		,1.1578119800e-04
		,1.1785579780e-04
		,1.1989334900e-04
		,1.2184080390e-04
		,1.2369939990e-04
		,1.2552688040e-04
		,1.2734776840e-04
		,1.2916369610e-04
		,1.3097055090e-04
		,1.3276383210e-04
		,1.3453992490e-04
		,1.3629016160e-04
		,1.3796411770e-04
		,1.3951022040e-04
		,1.4101696530e-04
		,1.4251179570e-04
		,1.4398119740e-04
		,1.4542913280e-04
		,1.4687310250e-04
		,1.4831872890e-04
		,1.4976542120e-04
		,1.5121087480e-04
		,1.5265336920e-04
		,1.5409300120e-04
		,1.5552996670e-04
		,1.5696365100e-04
		,1.5839293210e-04
		,1.5981633370e-04
		,1.6123181700e-04
		,1.6263587490e-04
		,1.6402094360e-04
		,1.6537585410e-04
		,1.6670208030e-04
		,1.6801083840e-04
		,1.6930996270e-04
		,1.7060225280e-04
		,1.7188819270e-04
		,1.7316758340e-04
		,1.7444001220e-04
		,1.7570503960e-04
		,1.7696228600e-04
		,1.7821139480e-04
		,1.7945193680e-04
		,1.8068341840e-04
		,1.8190533130e-04
		,1.8311718210e-04
		,1.8431852000e-04
		,1.8550897770e-04
		,1.8668823110e-04
		,1.8785568040e-04
		,1.8901030980e-04
		,1.9015089870e-04
		,1.9127589500e-04
		,1.9238334180e-04
		,1.9347269850e-04
		,1.9454584060e-04
		,1.9560454030e-04
		,1.9664967060e-04
		,1.9768170950e-04
		,1.9870099240e-04
		,1.9970765710e-04
		,2.0070163110e-04
		,2.0168267610e-04
		,2.0265042260e-04
		,2.0360445150e-04
		,2.0454442870e-04
		,2.0547002100e-04
		,2.0638078260e-04
		,2.0727615350e-04
		,2.0815548800e-04
		,2.0901806300e-04
		,2.0986300650e-04
		,2.1068927270e-04
		,2.1149581690e-04
		,2.1228177440e-04
		,2.1304669240e-04
		,2.1379081850e-04
		,2.1451524050e-04
		,2.1522177140e-04
		,2.1591261870e-04
		,2.1658991750e-04
		,2.1725531040e-04
		,2.1790899390e-04
		,2.1854967610e-04
		,2.1918109720e-04
		,2.1980642870e-04
		,2.2042759450e-04
		,2.2104659160e-04
		,2.2166582740e-04
		////////////////////////////////
		,-1.3577953560e-18
		,7.7404974960e-06
		,1.5137321690e-05
		,2.2215617790e-05
		,2.9005919460e-05
		,3.5539653990e-05
		,4.1844646770e-05
		,4.7937703910e-05
		,5.3811664570e-05
		,5.9420300500e-05
		,6.4713020430e-05
		,6.9722646560e-05
		,7.4523755510e-05
		,7.9165131470e-05
		,8.3670425580e-05
		,8.8047656750e-05
		,9.2296143760e-05
		,9.6412537370e-05
		,1.0039330750e-04
		,1.0423473370e-04
		,1.0793687400e-04
		,1.1150953330e-04
		,1.1496849690e-04
		,1.1832693680e-04
		,1.2159199910e-04
		,1.2476463930e-04
		,1.2783896050e-04
		,1.3080013370e-04
		,1.3362656010e-04
		,1.3631370890e-04
		,1.3889564930e-04
		,1.4141345970e-04
		,1.4389044290e-04
		,1.4633594410e-04
		,1.4875172560e-04
		,1.5113410590e-04
		,1.5347195170e-04
		,1.5574082900e-04
		,1.5790631900e-04
		,1.5995816440e-04
		,1.6192293580e-04
		,1.6382092660e-04
		,1.6565292280e-04
		,1.6740416900e-04
		,1.6905777770e-04
		,1.7063729160e-04
		,1.7218146580e-04
		,1.7370625420e-04
		,1.7521276920e-04
		,1.7669074210e-04
		,1.7809475630e-04
		,1.7935844300e-04
		,1.8056336180e-04
		,1.8175766490e-04
		,1.8294185930e-04
		,1.8411150640e-04
		,1.8526313110e-04
		,1.8639445110e-04
		,1.8750417400e-04
		,1.8859179380e-04
		,1.8965739770e-04
		,1.9070119430e-04
		,1.9172156960e-04
		,1.9271260130e-04
		,1.9367411440e-04
		,1.9461552060e-04
		,1.9554048270e-04
		,1.9644596070e-04
		,1.9732366620e-04
		,1.9817285890e-04
		,1.9900494600e-04
		,1.9982676690e-04
		,2.0064002200e-04
		,2.0144480730e-04
		,2.0224083990e-04
		,2.0302769950e-04
		,2.0380515600e-04
		,2.0457326340e-04
		,2.0533196810e-04
		,2.0608106070e-04
		,2.0682003450e-04
		,2.0754926790e-04
		,2.0826981530e-04
		,2.0898203940e-04
		,2.0968579690e-04
		,2.1038083680e-04
		,2.1106695230e-04
		,2.1174400060e-04
		,2.1241185830e-04
		,2.1307030450e-04
		,2.1371875940e-04
		,2.1435631450e-04
		,2.1498319790e-04
		,2.1560068740e-04
		,2.1620946500e-04
		,2.1680975800e-04
		,2.1740168350e-04
		,2.1798534500e-04
		,2.1856087340e-04
		,2.1912845850e-04
		,2.1968832530e-04
		,2.2024049790e-04
		,2.2078476700e-04
		,2.2132117810e-04
		,2.2185000440e-04
		,2.2237147440e-04
		,2.2288572490e-04
		,2.2339286750e-04
		,2.2389305390e-04
		,2.2438647010e-04
		,2.2487314910e-04
		,2.2535285280e-04
		,2.2582527350e-04
		,2.2629014640e-04
		,2.2674725010e-04
		,2.2719640980e-04
		,2.2763754690e-04
		,2.2807075400e-04
		,2.2849629380e-04
		,2.2891453870e-04
		,2.2932603470e-04
		////////////////////////////////
		,-2.5587718630e-18
		,1.8616075440e-14
		,3.1803893940e-14
		,4.1223779210e-14
		,4.8021828350e-14
		,5.3014496520e-14
		,5.6757992480e-14
		,5.9611251560e-14
		,6.1886579860e-14
		,6.3724387200e-14
		,6.5307222000e-14
		,6.6661088030e-14
		,6.7882011180e-14
		,6.8980539160e-14
		,7.0025440930e-14
		,7.1028726260e-14
		,7.1955305730e-14
		,7.2892119620e-14
		,7.3768101430e-14
		,7.4604189940e-14
		,7.5435109030e-14
		,7.6243261780e-14
		,7.7062954350e-14
		,7.7852570290e-14
		,7.8555820350e-14
		,7.9327108340e-14
		,8.0020489510e-14
		,8.0710894350e-14
		,8.1437694000e-14
		,8.2135461340e-14
		,8.2797825990e-14
		,8.3468023090e-14
		,8.4126053780e-14
		,8.4811654710e-14
		,8.5474854820e-14
		,8.6161186780e-14
		,8.6797808760e-14
		,8.7476621560e-14
		,8.8141910320e-14
		,8.8826884660e-14
		,8.9512381160e-14
		,9.0221636110e-14
		,9.0869484600e-14
		,9.1596754200e-14
		,9.2286323570e-14
		,9.2998189340e-14
		,9.3728121960e-14
		,9.4428917860e-14
		,9.5141932380e-14
		,9.5880585150e-14
		,9.6591719880e-14
		,9.7312671300e-14
		,9.8053517150e-14
		,9.8796033920e-14
		,9.9559280590e-14
		,1.0030252840e-13
		,1.0108410300e-13
		,1.0185032600e-13
		,1.0262182290e-13
		,1.0338809810e-13
		,1.0425530760e-13
		,1.0505876080e-13
		,1.0590106310e-13
		,1.0679270980e-13
		,1.0761031370e-13
		,1.0851214270e-13
		,1.0942028980e-13
		,1.1043673360e-13
		,1.1146429950e-13
		,1.1253891240e-13
		,1.1374061990e-13
		,1.1504817010e-13
		,1.1655137490e-13
		,1.1812042460e-13
		,1.2008981720e-13
		,1.2237172470e-13
		,1.2511961120e-13
		,1.2847989120e-13
		,1.3261125040e-13
		,1.3784792560e-13
		,1.4454049770e-13
		,1.5312372010e-13
		,1.6429431580e-13
		,1.7897223280e-13
		,1.9783832040e-13
		,2.1959672490e-13
		,2.4703110100e-13
		,2.8244847230e-13
		,3.2845354800e-13
		,3.8833319190e-13
		,4.6666839820e-13
		,5.6945747030e-13
		,7.0503189540e-13
		,8.8453798850e-13
		,1.1229514050e-12
		,1.4376855190e-12
		,1.8233275840e-12
		,2.3251143630e-12
		,2.9786515190e-12
		,3.8305027920e-12
		,4.9417773110e-12
		,6.3897185950e-12
		,8.2752777530e-12
		,1.0738406870e-11
		,1.3959650420e-11
		,1.8175476450e-11
		,2.3696500960e-11
		,3.0931689420e-11
		,4.0419354200e-11
		,5.2868326990e-11
		,6.9212480530e-11
		,9.0682927590e-11
		,1.1890324180e-10
		,1.5601522040e-10
		,2.0484584610e-10
		,2.6909793030e-10
		,3.5369405750e-10
		,4.6515438500e-10
		,6.1208026030e-10
		,8.0584629960e-10
		,1.0615014220e-09
		////////////////////////////////
		,-4.7011707560e-19
		,9.6206410430e-06
		,1.8874452850e-05
		,2.7779237460e-05
		,3.6349169220e-05
		,4.4589772530e-05
		,5.2493627000e-05
		,6.0045511930e-05
		,6.7245770840e-05
		,7.4123216320e-05
		,8.0716507690e-05
		,8.7056110270e-05
		,9.3156677560e-05
		,9.9010207000e-05
		,1.0461309760e-04
		,1.1000062340e-04
		,1.1520499920e-04
		,1.2024406410e-04
		,1.2512839790e-04
		,1.2986466330e-04
		,1.3445703690e-04
		,1.3890785920e-04
		,1.4321745950e-04
		,1.4738301800e-04
		,1.5139629590e-04
		,1.5524056610e-04
		,1.5889263720e-04
		,1.6234222500e-04
		,1.6560833840e-04
		,1.6872067210e-04
		,1.7170093990e-04
		,1.7456198420e-04
		,1.7731139400e-04
		,1.7995395760e-04
		,1.8249292250e-04
		,1.8493060790e-04
		,1.8726865980e-04
		,1.8950806060e-04
		,1.9164897750e-04
		,1.9369071640e-04
		,1.9563264230e-04
		,1.9747693890e-04
		,1.9923027340e-04
		,2.0090093440e-04
		,2.0249573650e-04
		,2.0401958570e-04
		,2.0547607660e-04
		,2.0686798060e-04
		,2.0819746460e-04
		,2.0946610360e-04
		,2.1067481460e-04
		,2.1182415670e-04
		,2.1291580180e-04
		,2.1395400960e-04
		,2.1494402640e-04
		,2.1588960630e-04
		,2.1679287040e-04
		,2.1765565410e-04
		,2.1848077270e-04
		,2.1927192340e-04
		,2.2003218570e-04
		,2.2076138790e-04
		,2.2145065410e-04
		,2.2208263020e-04
		,2.2263938340e-04
		,2.2316111130e-04
		,2.2367474520e-04
		,2.2418246810e-04
		,2.2468213680e-04
		,2.2517073210e-04
		,2.2564592380e-04
		,2.2610943230e-04
		,2.2656486910e-04
		,2.2701411130e-04
		,2.2745767200e-04
		,2.2789548330e-04
		,2.2832710770e-04
		,2.2875153790e-04
		,2.2916670850e-04
		,2.2957007940e-04
		,2.2996163230e-04
		,2.3034353140e-04
		,2.3071740400e-04
		,2.3108406810e-04
		,2.3144396430e-04
		,2.3179738600e-04
		,2.3214457030e-04
		,2.3248572800e-04
		,2.3282104040e-04
		,2.3315060870e-04
		,2.3347425290e-04
		,2.3379124910e-04
		,2.3410171570e-04
		,2.3440715890e-04
		,2.3470822820e-04
		,2.3500483320e-04
		,2.3529660710e-04
		,2.3558307050e-04
		,2.3586375300e-04
		,2.3613833940e-04
		,2.3640680910e-04
		,2.3666970230e-04
		,2.3692752210e-04
		,2.3718024680e-04
		,2.3742799700e-04
		,2.3767178670e-04
		,2.3791271310e-04
		,2.3815146110e-04
		,2.3838844640e-04
		,2.3862401290e-04
		,2.3885849460e-04
		,2.3909202150e-04
		,2.3932457770e-04
		,2.3955607630e-04
		,2.3978649310e-04
		,2.4001603270e-04
		,2.4024490420e-04
		,2.4047316680e-04
		,2.4070079600e-04
		,2.4092773310e-04
		,2.4115393640e-04
		////////////////////////////////
		,2.5899149510e-17
		,1.0304412160e-05
		,2.0230869540e-05
		,2.9787908760e-05
		,3.8976871780e-05
		,4.7793552810e-05
		,5.6237815270e-05
		,6.4322741290e-05
		,7.2071874200e-05
		,7.9511103250e-05
		,8.6664154870e-05
		,9.3551516580e-05
		,1.0019051580e-04
		,1.0659551640e-04
		,1.1277796780e-04
		,1.1874629110e-04
		,1.2450567100e-04
		,1.3005762040e-04
		,1.3539808000e-04
		,1.4051088640e-04
		,1.4535656680e-04
		,1.4989057170e-04
		,1.5412502400e-04
		,1.5811563790e-04
		,1.6191155030e-04
		,1.6554225790e-04
		,1.6902445660e-04
		,1.7236835920e-04
		,1.7558085580e-04
		,1.7866698660e-04
		,1.8163067500e-04
		,1.8447513210e-04
		,1.8720310090e-04
		,1.8981701430e-04
		,1.9231909500e-04
		,1.9471140850e-04
		,1.9699586700e-04
		,1.9917418020e-04
		,2.0124776620e-04
		,2.0321773090e-04
		,2.0508523460e-04
		,2.0685250250e-04
		,2.0852359520e-04
		,2.1010349970e-04
		,2.1159631070e-04
		,2.1300408410e-04
		,2.1432697260e-04
		,2.1556631730e-04
		,2.1672950930e-04
		,2.1782790800e-04
		,2.1887081560e-04
		,2.1986423510e-04
		,2.2081222170e-04
		,2.2171796020e-04
		,2.2258422230e-04
		,2.2341347860e-04
		,2.2420789660e-04
		,2.2496931970e-04
		,2.2569923630e-04
		,2.2639871480e-04
		,2.2706827820e-04
		,2.2770768580e-04
		,2.2831560750e-04
		,2.2888940280e-04
		,2.2942618770e-04
		,2.2992660910e-04
		,2.3039697840e-04
		,2.3084493730e-04
		,2.3127475830e-04
		,2.3168407170e-04
		,2.3205852470e-04
		,2.3239747670e-04
		,2.3272455200e-04
		,2.3304598620e-04
		,2.3336048970e-04
		,2.3367085430e-04
		,2.3397879500e-04
		,2.3428441240e-04
		,2.3458750490e-04
		,2.3488784970e-04
		,2.3518520850e-04
		,2.3547922910e-04
		,2.3576924840e-04
		,2.3605431750e-04
		,2.3633414490e-04
		,2.3660951030e-04
		,2.3688136180e-04
		,2.3715028330e-04
		,2.3741656560e-04
		,2.3768035940e-04
		,2.3794175640e-04
		,2.3820082550e-04
		,2.3845763120e-04
		,2.3871224140e-04
		,2.3896473050e-04
		,2.3921517930e-04
		,2.3946367590e-04
		,2.3971030770e-04
		,2.3995514030e-04
		,2.4019821060e-04
		,2.4043954480e-04
		,2.4067917320e-04
		,2.4091713390e-04
		,2.4115346390e-04
		,2.4138815830e-04
		,2.4162116570e-04
		,2.4185276060e-04
		,2.4208326960e-04
		,2.4231255250e-04
		,2.4254014510e-04
		,2.4276578220e-04
		,2.4298981500e-04
		,2.4321249470e-04
		,2.4343391980e-04
		,2.4365441280e-04
		,2.4387414740e-04
		,2.4409328660e-04
		,2.4431196920e-04
		,2.4453010430e-04
		,2.4474732430e-04
		,2.4496320160e-04
		////////////////////////////////
		,1.9580968800e-17
		,1.0891432990e-05
		,2.1389484030e-05
		,3.1495377530e-05
		,4.1211851380e-05
		,5.0546772420e-05
		,5.9513274460e-05
		,6.8127418950e-05
		,7.6406007480e-05
		,8.4365310810e-05
		,9.2020378350e-05
		,9.9384746680e-05
		,1.0646994440e-04
		,1.1328487460e-04
		,1.1983510800e-04
		,1.2612169890e-04
		,1.3213788850e-04
		,1.3786226570e-04
		,1.4326557810e-04
		,1.4835493730e-04
		,1.5317506240e-04
		,1.5776365880e-04
		,1.6214280430e-04
		,1.6632570150e-04
		,1.7032087490e-04
		,1.7413366410e-04
		,1.7776596290e-04
		,1.8121416280e-04
		,1.8446839240e-04
		,1.8752765420e-04
		,1.9041344940e-04
		,1.9314830410e-04
		,1.9574517160e-04
		,1.9821149210e-04
		,2.0055241740e-04
		,2.0277211260e-04
		,2.0487419970e-04
		,2.0686179410e-04
		,2.0873723160e-04
		,2.1050143180e-04
		,2.1215311470e-04
		,2.1369051080e-04
		,2.1512006340e-04
		,2.1645904930e-04
		,2.1772357670e-04
		,2.1892359450e-04
		,2.2006505600e-04
		,2.2115188960e-04
		,2.2218684200e-04
		,2.2317159610e-04
		,2.2410619340e-04
		,2.2498719390e-04
		,2.2580438220e-04
		,2.2654589720e-04
		,2.2722079210e-04
		,2.2785080000e-04
		,2.2844984680e-04
		,2.2902510310e-04
		,2.2958064370e-04
		,2.3011901990e-04
		,2.3064195550e-04
		,2.3115070060e-04
		,2.3164622500e-04
		,2.3212932850e-04
		,2.3260071320e-04
		,2.3306103490e-04
		,2.3351093580e-04
		,2.3395104950e-04
		,2.3438198220e-04
		,2.3480428650e-04
		,2.3521843620e-04
		,2.3562479750e-04
		,2.3602356720e-04
		,2.3641461120e-04
		,2.3679695880e-04
		,2.3716699610e-04
		,2.3751355320e-04
		,2.3782793200e-04
		,2.3812785720e-04
		,2.3842486590e-04
		,2.3872072870e-04
		,2.3901524580e-04
		,2.3930792620e-04
		,2.3959815030e-04
		,2.3988473330e-04
		,2.4016504600e-04
		,2.4043899950e-04
		,2.4070973180e-04
		,2.4097834210e-04
		,2.4124483080e-04
		,2.4150904990e-04
		,2.4177097620e-04
		,2.4203062880e-04
		,2.4228800070e-04
		,2.4254302930e-04
		,2.4279554140e-04
		,2.4304520440e-04
		,2.4329184480e-04
		,2.4353594310e-04
		,2.4377811010e-04
		,2.4401865850e-04
		,2.4425771320e-04
		,2.4449532600e-04
		,2.4473152320e-04
		,2.4496632350e-04
		,2.4519974590e-04
		,2.4543181470e-04
		,2.4566256310e-04
		,2.4589203370e-04
		,2.4612027630e-04
		,2.4634734380e-04
		,2.4657328800e-04
		,2.4679813650e-04
		,2.4702183580e-04
		,2.4724418200e-04
		,2.4746482250e-04
		,2.4768364280e-04
		,2.4790109600e-04
		,2.4811766110e-04
		,2.4833360630e-04
		,2.4854921020e-04
		////////////////////////////////
		,1.1852946130e-17
		,2.5362481230e-09
		,4.6879153080e-09
		,6.5751812750e-09
		,8.2953730260e-09
		,9.9262527530e-09
		,1.1531047240e-08
		,1.3161567200e-08
		,1.4859945180e-08
		,1.6659300710e-08
		,1.8581993160e-08
		,2.0639975620e-08
		,2.2847298280e-08
		,2.5232178380e-08
		,2.7828833190e-08
		,3.0666534230e-08
		,3.3764622080e-08
		,3.7127654650e-08
		,4.0737782660e-08
		,4.4550765050e-08
		,4.8517425000e-08
		,5.2628329560e-08
		,5.6916877270e-08
		,6.1416598390e-08
		,6.6142226190e-08
		,7.1104956300e-08
		,7.6337447850e-08
		,8.1897262810e-08
		,8.7851176890e-08
		,9.4263699550e-08
		,1.0119109450e-07
		,1.0868052740e-07
		,1.1677070060e-07
		,1.2549350990e-07
		,1.3487822280e-07
		,1.4495610320e-07
		,1.5575956750e-07
		,1.6731893970e-07
		,1.7967354760e-07
		,1.9289092080e-07
		,2.0706231430e-07
		,2.2228633820e-07
		,2.3866234670e-07
		,2.5629182660e-07
		,2.7528609070e-07
		,2.9577319860e-07
		,3.1789583970e-07
		,3.4180738670e-07
		,3.6767130180e-07
		,3.9566119100e-07
		,4.2595746160e-07
		,4.5873884260e-07
		,4.9416631040e-07
		,5.3235744450e-07
		,5.7336608050e-07
		,6.1722064000e-07
		,6.6404911640e-07
		,7.1415658490e-07
		,7.6795100960e-07
		,8.2585239700e-07
		,8.8827293200e-07
		,9.5564497340e-07
		,1.0285024040e-06
		,1.1074650500e-06
		,1.1931786770e-06
		,1.2861846740e-06
		,1.3868433170e-06
		,1.4954871500e-06
		,1.6132708460e-06
		,1.7426300400e-06
		,1.8868641990e-06
		,2.0510241580e-06
		,2.2416054210e-06
		,2.4657339130e-06
		,2.7313127510e-06
		,3.0482370600e-06
		,3.4281106210e-06
		,3.8818465020e-06
		,4.4284342000e-06
		,5.0877972550e-06
		,5.8835771270e-06
		,6.8436308510e-06
		,8.0004899160e-06
		,9.3874113150e-06
		,1.1047633210e-05
		,1.3027769620e-05
		,1.5363916110e-05
		,1.8110560190e-05
		,2.1286253100e-05
		,2.4961097150e-05
		,2.9206246330e-05
		,3.4079161690e-05
		,3.9615784080e-05
		,4.5808932880e-05
		,5.2471722690e-05
		,5.9409306710e-05
		,6.6631024570e-05
		,7.4123793280e-05
		,8.2263380090e-05
		,9.1190728850e-05
		,1.0095400450e-04
		,1.1157119570e-04
		,1.2305104230e-04
		,1.3539441190e-04
		,1.4860182110e-04
		,1.6266637000e-04
		,1.7757641310e-04
		,1.9331590620e-04
		,2.0986469340e-04
		,2.2719882350e-04
		,2.4529140900e-04
		,2.6411273150e-04
		,2.8363059430e-04
		,3.0381049280e-04
		,3.2461555200e-04
		,3.4600637400e-04
		,3.6753041310e-04
		,3.8951447190e-04
		,4.1189086920e-04
		,4.3463106900e-04
		,4.5772070030e-04
		////////////////////////////////
		,-1.8067033580e-17
		,9.5746394410e-09
		,1.7929285480e-08
		,2.5425449570e-08
		,3.2306475050e-08
		,3.8801677320e-08
		,4.5117320240e-08
		,5.1378951490e-08
		,5.7699181330e-08
		,6.4142622710e-08
		,7.0723200690e-08
		,7.7476741340e-08
		,8.4461700910e-08
		,9.1753606160e-08
		,9.9460320780e-08
		,1.0770193220e-07
		,1.1659149750e-07
		,1.2623784300e-07
		,1.3673981450e-07
		,1.4819081820e-07
		,1.6068929080e-07
		,1.7433935980e-07
		,1.8924541280e-07
		,2.0550830860e-07
		,2.2320947880e-07
		,2.4238707950e-07
		,2.6305664890e-07
		,2.8529634470e-07
		,3.0927452310e-07
		,3.3517581870e-07
		,3.6314851650e-07
		,3.9331784080e-07
		,4.2582881400e-07
		,4.6086200240e-07
		,4.9864000740e-07
		,5.3938630570e-07
		,5.8323763010e-07
		,6.3016590230e-07
		,6.7998328650e-07
		,7.3253295970e-07
		,7.8792271690e-07
		,8.4648764930e-07
		,9.0856847380e-07
		,9.7432051960e-07
		,1.0435616080e-06
		,1.1156298690e-06
		,1.1893506350e-06
		,1.2633940010e-06
		,1.3370927550e-06
		,1.4109633700e-06
		,1.4863051710e-06
		,1.5644946650e-06
		,1.6466465140e-06
		,1.7336053470e-06
		,1.8260321280e-06
		,1.9244685620e-06
		,2.0293533980e-06
		,2.1410276760e-06
		,2.2597770240e-06
		,2.3859452350e-06
		,2.5200465190e-06
		,2.6627581510e-06
		,2.8148584310e-06
		,2.9771863080e-06
		,3.1506487990e-06
		,3.3362431690e-06
		,3.5350920150e-06
		,3.7484910980e-06
		,3.9779666850e-06
		,4.2253489200e-06
		,4.4928666990e-06
		,4.7832688970e-06
		,5.1000013820e-06
		,5.4474390700e-06
		,5.8311718380e-06
		,6.2582696750e-06
		,6.7380294140e-06
		,7.2820651590e-06
		,7.9050807740e-06
		,8.6247327350e-06
		,9.4614433080e-06
		,1.0437527620e-05
		,1.1572511110e-05
		,1.2899624010e-05
		,1.4458940640e-05
		,1.6293979090e-05
		,1.8449632890e-05
		,2.0968980560e-05
		,2.3883927120e-05
		,2.7199435060e-05
		,3.0866374660e-05
		,3.4814732650e-05
		,3.9084882740e-05
		,4.3589800920e-05
		,4.8506433220e-05
		,5.3974909650e-05
		,6.0061947680e-05
		,6.6803329740e-05
		,7.4235195510e-05
		,8.2380622450e-05
		,9.1258544830e-05
		,1.0088415250e-04
		,1.1126886860e-04
		,1.2242026200e-04
		,1.3434197820e-04
		,1.4703320900e-04
		,1.6048877890e-04
		,1.7470301000e-04
		,1.8966431580e-04
		,2.0535773820e-04
		,2.2176512370e-04
		,2.3886520580e-04
		,2.5663355520e-04
		,2.7504281430e-04
		,2.9405846830e-04
		,3.1364382260e-04
		,3.3376779010e-04
		,3.5439980030e-04
		,3.7530992260e-04
		,3.9631538470e-04
		,4.1770902240e-04
		////////////////////////////////
		,-3.6568433030e-19
		,3.7079851030e-08
		,6.8427234330e-08
		,9.5999548290e-08
		,1.2131237230e-07
		,1.4549610020e-07
		,1.6935922920e-07
		,1.9352608510e-07
		,2.1861633950e-07
		,2.4514102830e-07
		,2.7336650120e-07
		,3.0292663590e-07
		,3.3355439660e-07
		,3.6556473880e-07
		,3.9953527400e-07
		,4.3580271780e-07
		,4.7489470370e-07
		,5.1760761650e-07
		,5.6467452270e-07
		,6.1656079150e-07
		,6.7332404850e-07
		,7.3445722610e-07
		,7.9885817080e-07
		,8.6518346760e-07
		,9.3265211900e-07
		,1.0013634370e-06
		,1.0716129850e-06
		,1.1434381410e-06
		,1.2170081480e-06
		,1.2931133200e-06
		,1.3730125090e-06
		,1.4579130990e-06
		,1.5487009390e-06
		,1.6459557170e-06
		,1.7500912620e-06
		,1.8615328630e-06
		,1.9807876270e-06
		,2.1083491130e-06
		,2.2445524280e-06
		,2.3896218830e-06
		,2.5438112960e-06
		,2.7074359390e-06
		,2.8810603820e-06
		,3.0653769130e-06
		,3.2609197860e-06
		,3.4680816440e-06
		,3.6874273940e-06
		,3.9198468150e-06
		,4.1663489030e-06
		,4.4277981000e-06
		,4.7047798950e-06
		,4.9975916850e-06
		,5.3063863860e-06
		,5.6314666970e-06
		,5.9734737410e-06
		,6.3331924420e-06
		,6.7111355480e-06
		,7.1072179870e-06
		,7.5207011170e-06
		,7.9506105680e-06
		,8.3966451840e-06
		,8.8597545340e-06
		,9.3417313580e-06
		,9.8444959510e-06
		,1.0369706230e-05
		,1.0918670360e-05
		,1.1492320820e-05
		,1.2091116460e-05
		,1.2714849210e-05
		,1.3362312330e-05
		,1.4031031060e-05
		,1.4716838910e-05
		,1.5413986690e-05
		,1.6116343760e-05
		,1.6819866730e-05
		,1.7524895600e-05
		,1.8235629900e-05
		,1.8957772880e-05
		,1.9697072990e-05
		,2.0459853850e-05
		,2.1255478220e-05
		,2.2097016690e-05
		,2.3000443410e-05
		,2.3984559280e-05
		,2.5070704440e-05
		,2.6283267490e-05
		,2.7650184900e-05
		,2.9203273000e-05
		,3.0977617780e-05
		,3.3011768650e-05
		,3.5347653330e-05
		,3.8027844390e-05
		,4.1094827190e-05
		,4.4588827660e-05
		,4.8548767530e-05
		,5.3005314850e-05
		,5.7996774190e-05
		,6.3555294530e-05
		,6.9708202750e-05
		,7.6479191290e-05
		,8.3888273160e-05
		,9.1951780290e-05
		,1.0068236250e-04
		,1.1008845680e-04
		,1.2017785510e-04
		,1.3095142330e-04
		,1.4240528540e-04
		,1.5453123550e-04
		,1.6731858700e-04
		,1.8075065520e-04
		,1.9482372700e-04
		,2.0952784400e-04
		,2.2484983780e-04
		,2.4077225130e-04
		,2.5727425380e-04
		,2.7432994630e-04
		,2.9196128050e-04
		,3.1010059260e-04
		,3.2873030750e-04
		,3.4783106660e-04
		,3.6737792460e-04
		////////////////////////////////
		,3.1851815640e-17
		,1.6878102470e-07
		,3.1273126630e-07
		,4.3918283830e-07
		,5.5409491370e-07
		,6.6202814200e-07
		,7.6680222850e-07
		,8.7138621160e-07
		,9.7765318810e-07
		,1.0864167400e-06
		,1.1973661100e-06
		,1.3101469700e-06
		,1.4264634530e-06
		,1.5489290070e-06
		,1.6788662960e-06
		,1.8171765360e-06
		,1.9651407600e-06
		,2.1220070030e-06
		,2.2848435750e-06
		,2.4573538470e-06
		,2.6440227090e-06
		,2.8452832460e-06
		,3.0603949280e-06
		,3.2884590620e-06
		,3.5294678060e-06
		,3.7849815180e-06
		,4.0580249270e-06
		,4.3522038960e-06
		,4.6699498500e-06
		,5.0119040640e-06
		,5.3776550730e-06
		,5.7664813340e-06
		,6.1771421500e-06
		,6.6069791580e-06
		,7.0512419810e-06
		,7.5042961850e-06
		,7.9630763890e-06
		,8.4292142710e-06
		,8.9072720110e-06
		,9.4018596320e-06
		,9.9159474290e-06
		,1.0450381590e-05
		,1.1003796390e-05
		,1.1572257540e-05
		,1.2149956890e-05
		,1.2732188050e-05
		,1.3316756900e-05
		,1.3904152500e-05
		,1.4496158770e-05
		,1.5094535280e-05
		,1.5701261730e-05
		,1.6319207610e-05
		,1.6951942480e-05
		,1.7603092090e-05
		,1.8275918160e-05
		,1.8972985550e-05
		,1.9695783900e-05
		,2.0444434260e-05
		,2.1217635890e-05
		,2.2013205930e-05
		,2.2829467890e-05
		,2.3666493550e-05
		,2.4525735590e-05
		,2.5408630810e-05
		,2.6315648500e-05
		,2.7246400510e-05
		,2.8200501490e-05
		,2.9178108420e-05
		,3.0180144950e-05
		,3.1207936680e-05
		,3.2262652460e-05
		,3.3345137680e-05
		,3.4456129540e-05
		,3.5596515250e-05
		,3.6767311060e-05
		,3.7969607330e-05
		,3.9204460550e-05
		,4.0472788040e-05
		,4.1775461710e-05
		,4.3113363090e-05
		,4.4487391900e-05
		,4.5898474160e-05
		,4.7347621910e-05
		,4.8836079200e-05
		,5.0365564020e-05
		,5.1938421720e-05
		,5.3557646150e-05
		,5.5230321320e-05
		,5.6966528060e-05
		,5.8778837190e-05
		,6.0683076840e-05
		,6.2698741070e-05
		,6.4849419010e-05
		,6.7163216960e-05
		,6.9673040200e-05
		,7.2416586410e-05
		,7.5435921420e-05
		,7.8776557460e-05
		,8.2486033580e-05
		,8.6612095580e-05
		,9.1200655150e-05
		,9.6293817870e-05
		,1.0192829250e-04
		,1.0813326570e-04
		,1.1493009010e-04
		,1.2233157780e-04
		,1.3034206790e-04
		,1.3896146480e-04
		,1.4818749900e-04
		,1.5804514360e-04
		,1.6848910520e-04
		,1.7950985570e-04
		,1.9111681600e-04
		,2.0329875060e-04
		,2.1602010040e-04
		,2.2925371560e-04
		,2.4295532400e-04
		,2.5708564020e-04
		,2.7157301740e-04
		,2.8628864440e-04
		,3.0128720400e-04
		////////////////////////////////
		,2.3444980150e-17
		,7.7130477450e-07
		,1.4368814200e-06
		,2.0284595090e-06
		,2.5766209640e-06
		,3.1021864370e-06
		,3.6145990820e-06
		,4.1184342930e-06
		,4.6232177860e-06
		,5.1434820830e-06
		,5.6913958950e-06
		,6.2697179220e-06
		,6.8646587740e-06
		,7.4526142140e-06
		,8.0321867990e-06
		,8.6201769290e-06
		,9.2251186980e-06
		,9.8443535550e-06
		,1.0474716830e-05
		,1.1121484820e-05
		,1.1795301870e-05
		,1.2503289650e-05
		,1.3239073290e-05
		,1.3992559340e-05
		,1.4765097960e-05
		,1.5541142210e-05
		,1.6312624150e-05
		,1.7089610100e-05
		,1.7877102650e-05
		,1.8683215970e-05
		,1.9515201690e-05
		,2.0378374780e-05
		,2.1277484690e-05
		,2.2216687140e-05
		,2.3199172410e-05
		,2.4227409720e-05
		,2.5302937360e-05
		,2.6425256320e-05
		,2.7590517670e-05
		,2.8791377390e-05
		,3.0019044810e-05
		,3.1266109590e-05
		,3.2527637820e-05
		,3.3800385810e-05
		,3.5082306460e-05
		,3.6372333370e-05
		,3.7670189660e-05
		,3.8976970810e-05
		,4.0294717690e-05
		,4.1626332110e-05
		,4.2978010860e-05
		,4.4353975240e-05
		,4.5755904130e-05
		,4.7185335850e-05
		,4.8644014520e-05
		,5.0133220340e-05
		,5.1653584820e-05
		,5.3205441870e-05
		,5.4789057630e-05
		,5.6404375180e-05
		,5.8050559280e-05
		,5.9725767500e-05
		,6.1427264100e-05
		,6.3151769960e-05
		,6.4895899090e-05
		,6.6656536150e-05
		,6.8430956890e-05
		,7.0216473780e-05
		,7.2009577610e-05
		,7.3805172980e-05
		,7.5598084760e-05
		,7.7386209390e-05
		,7.9170691210e-05
		,8.0954880770e-05
		,8.2742412980e-05
		,8.4535316500e-05
		,8.6333123670e-05
		,8.8133018980e-05
		,8.9931020730e-05
		,9.1723876110e-05
		,9.3510428350e-05
		,9.5290885030e-05
		,9.7064881320e-05
		,9.8830502450e-05
		,1.0058470110e-04
		,1.0232454130e-04
		,1.0404821930e-04
		,1.0575531620e-04
		,1.0744675460e-04
		,1.0912502940e-04
		,1.1079451280e-04
		,1.1246108810e-04
		,1.1413004460e-04
		,1.1580643490e-04
		,1.1750157970e-04
		,1.1922549520e-04
		,1.2098767580e-04
		,1.2279845640e-04
		,1.2466961810e-04
		,1.2661502960e-04
		,1.2865138690e-04
		,1.3079912880e-04
		,1.3308405500e-04
		,1.3553668190e-04
		,1.3819323310e-04
		,1.4109539830e-04
		,1.4428902580e-04
		,1.4782254260e-04
		,1.5174520140e-04
		,1.5610534920e-04
		,1.6094884110e-04
		,1.6631769390e-04
		,1.7224908160e-04
		,1.7877471320e-04
		,1.8592060310e-04
		,1.9370717660e-04
		,2.0214965250e-04
		,2.1125855880e-04
		,2.2104032670e-04
		,2.3149785730e-04
		,2.4263105800e-04
		////////////////////////////////
		,-1.5351782370e-17
		,2.6193821360e-06
		,5.0690727070e-06
		,7.3803263740e-06
		,9.5786522200e-06
		,1.1659945160e-05
		,1.3595713520e-05
		,1.5461815020e-05
		,1.7332874250e-05
		,1.9233550000e-05
		,2.1158999960e-05
		,2.3093309780e-05
		,2.5024841110e-05
		,2.6934207450e-05
		,2.8799115610e-05
		,3.0633796190e-05
		,3.2474267300e-05
		,3.4334299790e-05
		,3.6198479200e-05
		,3.8028615060e-05
		,3.9811704230e-05
		,4.1599513070e-05
		,4.3433646330e-05
		,4.5331312810e-05
		,4.7295423710e-05
		,4.9307143810e-05
		,5.1293910460e-05
		,5.3149968760e-05
		,5.4900409650e-05
		,5.6616007220e-05
		,5.8320318360e-05
		,5.9991853670e-05
		,6.1581252300e-05
		,6.3146251790e-05
		,6.4726245450e-05
		,6.6330342660e-05
		,6.7966444050e-05
		,6.9646084090e-05
		,7.1373784060e-05
		,7.3147379800e-05
		,7.4965422120e-05
		,7.6828630980e-05
		,7.8735796240e-05
		,8.0677534910e-05
		,8.2630734900e-05
		,8.4559452400e-05
		,8.6432594540e-05
		,8.8242903280e-05
		,9.0005188500e-05
		,9.1742638350e-05
		,9.3476655890e-05
		,9.5222551280e-05
		,9.6987384750e-05
		,9.8769332230e-05
		,1.0057087280e-04
		,1.0240105750e-04
		,1.0426158500e-04
		,1.0614712710e-04
		,1.0804867510e-04
		,1.0995815650e-04
		,1.1187095150e-04
		,1.1378326120e-04
		,1.1568900030e-04
		,1.1758028170e-04
		,1.1945124930e-04
		,1.2130062900e-04
		,1.2312970740e-04
		,1.2494002950e-04
		,1.2673425170e-04
		,1.2851732380e-04
		,1.3029523530e-04
		,1.3207344740e-04
		,1.3385682010e-04
		,1.3564942620e-04
		,1.3745369980e-04
		,1.3927255450e-04
		,1.4111113790e-04
		,1.4297379280e-04
		,1.4486327860e-04
		,1.4678121060e-04
		,1.4872833630e-04
		,1.5070462640e-04
		,1.5270915200e-04
		,1.5473981420e-04
		,1.5679326640e-04
		,1.5886536600e-04
		,1.6095141310e-04
		,1.6304651860e-04
		,1.6514655940e-04
		,1.6724871920e-04
		,1.6935102970e-04
		,1.7145133300e-04
		,1.7354635960e-04
		,1.7563138300e-04
		,1.7770078310e-04
		,1.7974956230e-04
		,1.8177489870e-04
		,1.8377618150e-04
		,1.8575232380e-04
		,1.8769633310e-04
		,1.8961002430e-04
		,1.9150286730e-04
		,1.9338172030e-04
		,1.9525473720e-04
		,1.9713157020e-04
		,1.9902374410e-04
		,2.0094539030e-04
		,2.0291380120e-04
		,2.0494922860e-04
		,2.0707505160e-04
		,2.0931794580e-04
		,2.1170847240e-04
		,2.1428108000e-04
		,2.1707387350e-04
		,2.2012813000e-04
		,2.2348781590e-04
		,2.2719857610e-04
		,2.3130613740e-04
		,2.3585506220e-04
		,2.4088734010e-04
		,2.4644106220e-04
		////////////////////////////////
		,7.2056892400e-18
		,5.4153873480e-06
		,1.0484943410e-05
		,1.5248805350e-05
		,1.9787930310e-05
		,2.4157306960e-05
		,2.8343916560e-05
		,3.2326744680e-05
		,3.6060199780e-05
		,3.9417119680e-05
		,4.2505487740e-05
		,4.5492922730e-05
		,4.8441992440e-05
		,5.1368295570e-05
		,5.4271338140e-05
		,5.7155083170e-05
		,6.0012633430e-05
		,6.2802143250e-05
		,6.5533139450e-05
		,6.8252113190e-05
		,7.0976964530e-05
		,7.3708074780e-05
		,7.6438458270e-05
		,7.9157094470e-05
		,8.1851715230e-05
		,8.4513729540e-05
		,8.7142934090e-05
		,8.9742675990e-05
		,9.2309638030e-05
		,9.4828925930e-05
		,9.7266610570e-05
		,9.9564674150e-05
		,1.0173749530e-04
		,1.0382860680e-04
		,1.0586987740e-04
		,1.0789920850e-04
		,1.0992124310e-04
		,1.1190254910e-04
		,1.1376673690e-04
		,1.1558972330e-04
		,1.1743610130e-04
		,1.1931120600e-04
		,1.2121503640e-04
		,1.2314523680e-04
		,1.2509575930e-04
		,1.2705780960e-04
		,1.2902220530e-04
		,1.3098460510e-04
		,1.3294656400e-04
		,1.3490871160e-04
		,1.3687514960e-04
		,1.3885446690e-04
		,1.4084970930e-04
		,1.4286101100e-04
		,1.4488890890e-04
		,1.4693385570e-04
		,1.4899237710e-04
		,1.5105262630e-04
		,1.5310493590e-04
		,1.5516100920e-04
		,1.5723196270e-04
		,1.5932163790e-04
		,1.6143062180e-04
		,1.6355776680e-04
		,1.6570075420e-04
		,1.6785620200e-04
		,1.7001967750e-04
		,1.7218605170e-04
		,1.7435030030e-04
		,1.7650870350e-04
		,1.7866031550e-04
		,1.8080770500e-04
		,1.8295540970e-04
		,1.8510768260e-04
		,1.8726838800e-04
		,1.8944144960e-04
		,1.9162961940e-04
		,1.9383335390e-04
		,1.9605035970e-04
		,1.9827668330e-04
		,2.0051210300e-04
		,2.0275914790e-04
		,2.0501835770e-04
		,2.0728836670e-04
		,2.0956654060e-04
		,2.1184895050e-04
		,2.1412990610e-04
		,2.1640124280e-04
		,2.1865196420e-04
		,2.2086985340e-04
		,2.2304594150e-04
		,2.2517867920e-04
		,2.2727447920e-04
		,2.2934428980e-04
		,2.3139964660e-04
		,2.3345064830e-04
		,2.3550537530e-04
		,2.3756997710e-04
		,2.3964895160e-04
		,2.4174548550e-04
		,2.4386181580e-04
		,2.4599952600e-04
		,2.4815972870e-04
		,2.5034307760e-04
		,2.5254911310e-04
		,2.5477158480e-04
		,2.5699764310e-04
		,2.5923729610e-04
		,2.6149758730e-04
		,2.6377915530e-04
		,2.6608135010e-04
		,2.6840324750e-04
		,2.7074412690e-04
		,2.7310384890e-04
		,2.7548317600e-04
		,2.7788411740e-04
		,2.8031083950e-04
		,2.8277061240e-04
		,2.8527504370e-04
		,2.8784034140e-04
		,2.9048790860e-04
		////////////////////////////////
		,-5.2740230660e-18
		,7.1824172620e-06
		,1.4067832000e-05
		,2.0703615330e-05
		,2.7136326700e-05
		,3.3406429510e-05
		,3.9543894220e-05
		,4.5562201870e-05
		,5.1445184310e-05
		,5.7113801220e-05
		,6.2438120510e-05
		,6.7423473930e-05
		,7.2167483300e-05
		,7.6706382580e-05
		,8.1036054410e-05
		,8.5161454010e-05
		,8.9079667910e-05
		,9.2761547300e-05
		,9.6258880430e-05
		,9.9692686630e-05
		,1.0312885490e-04
		,1.0658366340e-04
		,1.1005358940e-04
		,1.1352778730e-04
		,1.1699301590e-04
		,1.2043600210e-04
		,1.2384230450e-04
		,1.2719580740e-04
		,1.3048662650e-04
		,1.3369346240e-04
		,1.3677504710e-04
		,1.3968882210e-04
		,1.4247549580e-04
		,1.4518181480e-04
		,1.4775828640e-04
		,1.5018787930e-04
		,1.5256580180e-04
		,1.5494565040e-04
		,1.5733494040e-04
		,1.5972760040e-04
		,1.6211528760e-04
		,1.6449118740e-04
		,1.6684295080e-04
		,1.6909855300e-04
		,1.7115187790e-04
		,1.7314586200e-04
		,1.7515032020e-04
		,1.7716541520e-04
		,1.7918043020e-04
		,1.8117508130e-04
		,1.8313918090e-04
		,1.8509525000e-04
		,1.8705918900e-04
		,1.8903412600e-04
		,1.9101891770e-04
		,1.9301182170e-04
		,1.9501249070e-04
		,1.9702108320e-04
		,1.9903655520e-04
		,2.0105603370e-04
		,2.0307291520e-04
		,2.0507132100e-04
		,2.0703066120e-04
		,2.0896074720e-04
		,2.1088370560e-04
		,2.1280844070e-04
		,2.1473622610e-04
		,2.1666553660e-04
		,2.1859780790e-04
		,2.2053551170e-04
		,2.2247919370e-04
		,2.2442867080e-04
		,2.2638359250e-04
		,2.2834363470e-04
		,2.3030859050e-04
		,2.3227833230e-04
		,2.3425259880e-04
		,2.3623089550e-04
		,2.3821262750e-04
		,2.4019707370e-04
		,2.4218328530e-04
		,2.4416995740e-04
		,2.4615478240e-04
		,2.4813346020e-04
		,2.5010234400e-04
		,2.5206412520e-04
		,2.5402255390e-04
		,2.5597871310e-04
		,2.5793266310e-04
		,2.5988447340e-04
		,2.6183440980e-04
		,2.6378275640e-04
		,2.6572950690e-04
		,2.6767420500e-04
		,2.6961653810e-04
		,2.7155715290e-04
		,2.7349694710e-04
		,2.7543637650e-04
		,2.7737550000e-04
		,2.7931416240e-04
		,2.8125213160e-04
		,2.8318918550e-04
		,2.8512509420e-04
		,2.8705941180e-04
		,2.8899130510e-04
		,2.9091970500e-04
		,2.9284349370e-04
		,2.9476152860e-04
		,2.9667259320e-04
		,2.9857533130e-04
		,3.0046809620e-04
		,3.0234807660e-04
		,3.0420586260e-04
		,3.0602939340e-04
		,3.0783137620e-04
		,3.0961989160e-04
		,3.1139864660e-04
		,3.1317119510e-04
		,3.1494134300e-04
		,3.1671333940e-04
		,3.1849201550e-04
		////////////////////////////////
		,-5.3262394360e-18
		,8.7519068430e-06
		,1.7163923410e-05
		,2.5279923060e-05
		,3.3141924130e-05
		,4.0784364460e-05
		,4.8227380560e-05
		,5.5465128860e-05
		,6.2441747190e-05
		,6.9052250800e-05
		,7.5277474290e-05
		,8.1223545120e-05
		,8.6978682900e-05
		,9.2589311910e-05
		,9.8078865350e-05
		,1.0345618680e-04
		,1.0872087190e-04
		,1.1386688420e-04
		,1.1888571130e-04
		,1.2377494730e-04
		,1.2854658930e-04
		,1.3322012600e-04
		,1.3781081680e-04
		,1.4232558660e-04
		,1.4676278670e-04
		,1.5111118590e-04
		,1.5534740660e-04
		,1.5943798680e-04
		,1.6336681990e-04
		,1.6717034310e-04
		,1.7090467040e-04
		,1.7460339620e-04
		,1.7827814930e-04
		,1.8192668290e-04
		,1.8553162150e-04
		,1.8905184460e-04
		,1.9243796280e-04
		,1.9569265200e-04
		,1.9885592510e-04
		,2.0194760770e-04
		,2.0496260260e-04
		,2.0790846050e-04
		,2.1079037620e-04
		,2.1359542040e-04
		,2.1629490900e-04
		,2.1888614850e-04
		,2.2141746250e-04
		,2.2391487630e-04
		,2.2632329580e-04
		,2.2846536490e-04
		,2.3046048230e-04
		,2.3247219970e-04
		,2.3451204850e-04
		,2.3656973940e-04
		,2.3863647120e-04
		,2.4070663460e-04
		,2.4277676620e-04
		,2.4484447970e-04
		,2.4690793940e-04
		,2.4896562650e-04
		,2.5101622230e-04
		,2.5305862680e-04
		,2.5509174740e-04
		,2.5711288180e-04
		,2.5911361210e-04
		,2.6107011620e-04
		,2.6293643430e-04
		,2.6470672220e-04
		,2.6643696820e-04
		,2.6816055350e-04
		,2.6988592080e-04
		,2.7161367230e-04
		,2.7334254200e-04
		,2.7507103910e-04
		,2.7679778260e-04
		,2.7852143500e-04
		,2.8024071330e-04
		,2.8195429790e-04
		,2.8366066660e-04
		,2.8535970370e-04
		,2.8705142240e-04
		,2.8873535990e-04
		,2.9041088910e-04
		,2.9207710760e-04
		,2.9373221970e-04
		,2.9537415130e-04
		,2.9700321590e-04
		,2.9861791770e-04
		,3.0021283860e-04
		,3.0178350250e-04
		,3.0333335400e-04
		,3.0486651080e-04
		,3.0638405840e-04
		,3.0788573580e-04
		,3.0937107020e-04
		,3.1083979490e-04
		,3.1229182530e-04
		,3.1372677680e-04
		,3.1514360320e-04
		,3.1654166310e-04
		,3.1792212900e-04
		,3.1928679740e-04
		,3.2063717240e-04
		,3.2197455440e-04
		,3.2330009340e-04
		,3.2461484360e-04
		,3.2591983410e-04
		,3.2721617400e-04
		,3.2850509310e-04
		,3.2978751230e-04
		,3.3106334530e-04
		,3.3233190100e-04
		,3.3359266220e-04
		,3.3484544670e-04
		,3.3609034400e-04
		,3.3732765530e-04
		,3.3855779300e-04
		,3.3978098280e-04
		,3.4099639210e-04
		,3.4219820960e-04
		,3.4337565090e-04
		////////////////////////////////
		,7.7800692940e-18
		,1.8615971010e-14
		,3.1802431880e-14
		,4.1223779210e-14
		,4.8022402730e-14
		,5.3014183220e-14
		,5.6758566860e-14
		,5.9613810160e-14
		,6.1886475420e-14
		,6.3724752710e-14
		,6.5306229890e-14
		,6.6674507640e-14
		,6.7881019070e-14
		,6.8979494840e-14
		,7.0036563020e-14
		,7.1027890800e-14
		,7.1955305730e-14
		,7.2891127510e-14
		,7.3766952670e-14
		,7.4617505120e-14
		,7.5435109030e-14
		,7.6242374100e-14
		,7.7063163210e-14
		,7.7847244220e-14
		,7.8555715920e-14
		,7.9327421640e-14
		,8.0017565400e-14
		,8.0712147540e-14
		,8.1448137270e-14
		,8.2135356910e-14
		,8.2795632900e-14
		,8.3462853670e-14
		,8.4120309980e-14
		,8.4810036000e-14
		,8.5473706060e-14
		,8.6150639070e-14
		,8.6794466910e-14
		,8.7474167390e-14
		,8.8142014760e-14
		,8.8826780230e-14
		,8.9511911210e-14
		,9.0207328820e-14
		,9.0864941780e-14
		,9.1598268470e-14
		,9.2279274360e-14
		,9.2998502630e-14
		,9.3730732780e-14
		,9.4421398700e-14
		,9.5141932380e-14
		,9.5861265090e-14
		,9.6593756320e-14
		,9.7321130350e-14
		,9.8053308280e-14
		,9.8796033920e-14
		,9.9550299380e-14
		,1.0030362490e-13
		,1.0106838590e-13
		,1.0182578430e-13
		,1.0262224060e-13
		,1.0337718490e-13
		,1.0423181020e-13
		,1.0505876080e-13
		,1.0590043650e-13
		,1.0676101450e-13
		,1.0760112370e-13
		,1.0851193380e-13
		,1.0942258730e-13
		,1.1043490600e-13
		,1.1146429950e-13
		,1.1255107880e-13
		,1.1377602260e-13
		,1.1503459380e-13
		,1.1652291700e-13
		,1.1812376640e-13
		,1.2009112260e-13
		,1.2236138590e-13
		,1.2512008110e-13
		,1.2849785360e-13
		,1.3260540210e-13
		,1.3785105860e-13
		,1.4454195980e-13
		,1.5310983050e-13
		,1.6430423690e-13
		,1.7897494810e-13
		,1.9784599620e-13
		,2.1960596720e-13
		,2.4703940340e-13
		,2.8248126420e-13
		,3.2847735870e-13
		,3.8833178200e-13
		,4.6667393320e-13
		,5.6945861910e-13
		,7.0503513280e-13
		,8.8453819740e-13
		,1.1229641980e-12
		,1.4376858850e-12
		,1.8233415780e-12
		,2.3251143630e-12
		,2.9786516240e-12
		,3.8304998680e-12
		,4.9417681210e-12
		,6.3897239210e-12
		,8.2752856900e-12
		,1.0738407920e-11
		,1.3959647500e-11
		,1.8175475400e-11
		,2.3696512500e-11
		,3.0931674270e-11
		,4.0419334350e-11
		,5.2868302340e-11
		,6.9212476090e-11
		,9.0682937350e-11
		,1.1890325080e-10
		,1.5601522070e-10
		,2.0484584980e-10
		,2.6909793120e-10
		,3.5369404660e-10
		,4.6515438690e-10
		,6.1208025950e-10
		,8.0584630770e-10
		,1.0615014110e-09
		////////////////////////////////
		,-1.3054262120e-17
		,1.1126045810e-05
		,2.1875105040e-05
		,3.2258147400e-05
		,4.2279664030e-05
		,5.1931448000e-05
		,6.1186563580e-05
		,7.0021915700e-05
		,7.8464739220e-05
		,8.6577595150e-05
		,9.4415180390e-05
		,1.0200917910e-04
		,1.0935896810e-04
		,1.1644563440e-04
		,1.2330428780e-04
		,1.2998735840e-04
		,1.3652562610e-04
		,1.4293770980e-04
		,1.4923637590e-04
		,1.5543074550e-04
		,1.6152726980e-04
		,1.6753038050e-04
		,1.7344307160e-04
		,1.7926740070e-04
		,1.8500479020e-04
		,1.9065607600e-04
		,1.9622139470e-04
		,2.0170003950e-04
		,2.0709035380e-04
		,2.1238966970e-04
		,2.1759423620e-04
		,2.2269896210e-04
		,2.2769659070e-04
		,2.3257586100e-04
		,2.3731917030e-04
		,2.4190399060e-04
		,2.4631236330e-04
		,2.5053573720e-04
		,2.5457117060e-04
		,2.5842789640e-04
		,2.6213134940e-04
		,2.6571123740e-04
		,2.6919064450e-04
		,2.7258441960e-04
		,2.7590138080e-04
		,2.7914642360e-04
		,2.8232177170e-04
		,2.8542758700e-04
		,2.8846247130e-04
		,2.9142493000e-04
		,2.9431648500e-04
		,2.9714327170e-04
		,2.9991267510e-04
		,3.0262931190e-04
		,3.0529389570e-04
		,3.0790288860e-04
		,3.1044548030e-04
		,3.1288931590e-04
		,3.1512660780e-04
		,3.1703109090e-04
		,3.1880049900e-04
		,3.2056550600e-04
		,3.2233007410e-04
		,3.2407721450e-04
		,3.2578073010e-04
		,3.2742973620e-04
		,3.2904414460e-04
		,3.3063309930e-04
		,3.3219694270e-04
		,3.3373358490e-04
		,3.3523939000e-04
		,3.3670915230e-04
		,3.3813950760e-04
		,3.3953294610e-04
		,3.4089349910e-04
		,3.4222477490e-04
		,3.4352969220e-04
		,3.4480996590e-04
		,3.4606652960e-04
		,3.4729997330e-04
		,3.4851075210e-04
		,3.4969927060e-04
		,3.5086593800e-04
		,3.5201120620e-04
		,3.5313555600e-04
		,3.5423944880e-04
		,3.5532330270e-04
		,3.5638749940e-04
		,3.5743239960e-04
		,3.5845835820e-04
		,3.5946574150e-04
		,3.6045494410e-04
		,3.6142637750e-04
		,3.6238037610e-04
		,3.6331705620e-04
		,3.6423621340e-04
		,3.6513710770e-04
		,3.6601839130e-04
		,3.6687951930e-04
		,3.6772065920e-04
		,3.6854304730e-04
		,3.6934918390e-04
		,3.7014079740e-04
		,3.7091862710e-04
		,3.7168223360e-04
		,3.7242940450e-04
		,3.7316210370e-04
		,3.7388246480e-04
		,3.7459084100e-04
		,3.7528633530e-04
		,3.7596780600e-04
		,3.7663602920e-04
		,3.7729373570e-04
		,3.7794320410e-04
		,3.7858558350e-04
		,3.7922143490e-04
		,3.7985115600e-04
		,3.8047481180e-04
		,3.8109235590e-04
		,3.8170394690e-04
		,3.8230984650e-04
		////////////////////////////////
		,2.7672978320e-18
		,1.1980147880e-05
		,2.3550114030e-05
		,3.4709633760e-05
		,4.5449390290e-05
		,5.5756597150e-05
		,6.5635645280e-05
		,7.5118034450e-05
		,8.4246928970e-05
		,9.3063106900e-05
		,1.0160138980e-04
		,1.0989118470e-04
		,1.1795749150e-04
		,1.2582159030e-04
		,1.3350136830e-04
		,1.4101126240e-04
		,1.4836151920e-04
		,1.5555563730e-04
		,1.6258267920e-04
		,1.6940620180e-04
		,1.7600280550e-04
		,1.8241654710e-04
		,1.8869410060e-04
		,1.9485781100e-04
		,2.0091767640e-04
		,2.0687797850e-04
		,2.1273939730e-04
		,2.1849936870e-04
		,2.2415124800e-04
		,2.2968180060e-04
		,2.3506671150e-04
		,2.4026869130e-04
		,2.4525402490e-04
		,2.5002326900e-04
		,2.5460661580e-04
		,2.5903745490e-04
		,2.6334329070e-04
		,2.6754388800e-04
		,2.7165132610e-04
		,2.7567221990e-04
		,2.7960996790e-04
		,2.8346617200e-04
		,2.8724140630e-04
		,2.9093564020e-04
		,2.9454853610e-04
		,2.9807975800e-04
		,3.0152930210e-04
		,3.0489771470e-04
		,3.0818603500e-04
		,3.1139549290e-04
		,3.1452717340e-04
		,3.1758181540e-04
		,3.2055975860e-04
		,3.2346097430e-04
		,3.2628511640e-04
		,3.2903154980e-04
		,3.3169932570e-04
		,3.3428705780e-04
		,3.3679260580e-04
		,3.3921231310e-04
		,3.4153899320e-04
		,3.4375530590e-04
		,3.4580795290e-04
		,3.4757085370e-04
		,3.4909389800e-04
		,3.5057420710e-04
		,3.5205211970e-04
		,3.5352000430e-04
		,3.5496799240e-04
		,3.5638868760e-04
		,3.5777677580e-04
		,3.5912833490e-04
		,3.6044035290e-04
		,3.6171042220e-04
		,3.6293630590e-04
		,3.6411413210e-04
		,3.6523384520e-04
		,3.6629283910e-04
		,3.6731040080e-04
		,3.6829803310e-04
		,3.6925946890e-04
		,3.7019628090e-04
		,3.7110923160e-04
		,3.7199842930e-04
		,3.7286319650e-04
		,3.7370266430e-04
		,3.7451817200e-04
		,3.7531346810e-04
		,3.7609165590e-04
		,3.7685437160e-04
		,3.7760244830e-04
		,3.7833639590e-04
		,3.7905661040e-04
		,3.7976345450e-04
		,3.8045728340e-04
		,3.8113845410e-04
		,3.8180733030e-04
		,3.8246427700e-04
		,3.8310963780e-04
		,3.8374371180e-04
		,3.8436674140e-04
		,3.8497889200e-04
		,3.8558019100e-04
		,3.8617038900e-04
		,3.8674879420e-04
		,3.8731474230e-04
		,3.8786914720e-04
		,3.8841409980e-04
		,3.8895099450e-04
		,3.8948031410e-04
		,3.9000205440e-04
		,3.9051599920e-04
		,3.9102216980e-04
		,3.9152081650e-04
		,3.9201166290e-04
		,3.9249363180e-04
		,3.9296456490e-04
		,3.9342071150e-04
		,3.9386237360e-04
		,3.9429519500e-04
		,3.9472130380e-04
		////////////////////////////////
		,1.9318359200e-18
		,1.2701137750e-05
		,2.4964441410e-05
		,3.6780996150e-05
		,4.8151560880e-05
		,5.9090986890e-05
		,6.9624587300e-05
		,7.9781504580e-05
		,8.9590675000e-05
		,9.9079370040e-05
		,1.0827282820e-04
		,1.1719446320e-04
		,1.2586587290e-04
		,1.3430674850e-04
		,1.4253491080e-04
		,1.5056630290e-04
		,1.5841497750e-04
		,1.6609308770e-04
		,1.7361086050e-04
		,1.8097650520e-04
		,1.8819597270e-04
		,1.9527243380e-04
		,2.0220520060e-04
		,2.0898740790e-04
		,2.1560067150e-04
		,2.2200370420e-04
		,2.2812435130e-04
		,2.3391109830e-04
		,2.3940263980e-04
		,2.4467589310e-04
		,2.4978696900e-04
		,2.5476542090e-04
		,2.5962412190e-04
		,2.6436794110e-04
		,2.6900096400e-04
		,2.7353011270e-04
		,2.7796316510e-04
		,2.8230591840e-04
		,2.8656167960e-04
		,2.9073193420e-04
		,2.9481703010e-04
		,2.9881662130e-04
		,3.0272992990e-04
		,3.0655590290e-04
		,3.1029331370e-04
		,3.1394083340e-04
		,3.1749708760e-04
		,3.2096070450e-04
		,3.2433035740e-04
		,3.2760480290e-04
		,3.3078291290e-04
		,3.3386369680e-04
		,3.3684631350e-04
		,3.3973006770e-04
		,3.4251439010e-04
		,3.4519879330e-04
		,3.4778278300e-04
		,3.5026567940e-04
		,3.5264628360e-04
		,3.5492243530e-04
		,3.5709105210e-04
		,3.5915021550e-04
		,3.6110322090e-04
		,3.6295869630e-04
		,3.6472437050e-04
		,3.6640019680e-04
		,3.6796809660e-04
		,3.6936594420e-04
		,3.7054694370e-04
		,3.7164580310e-04
		,3.7273913970e-04
		,3.7382682680e-04
		,3.7489961000e-04
		,3.7595030910e-04
		,3.7697450240e-04
		,3.7797032190e-04
		,3.7893771260e-04
		,3.7987729120e-04
		,3.8078959610e-04
		,3.8167488130e-04
		,3.8253312800e-04
		,3.8336405790e-04
		,3.8416706240e-04
		,3.8494097620e-04
		,3.8568380330e-04
		,3.8639269950e-04
		,3.8706433350e-04
		,3.8769474840e-04
		,3.8827953260e-04
		,3.8882609230e-04
		,3.8934816830e-04
		,3.8985273280e-04
		,3.9034321670e-04
		,3.9082170440e-04
		,3.9128959450e-04
		,3.9174784680e-04
		,3.9219707510e-04
		,3.9263755070e-04
		,3.9306927400e-04
		,3.9349254250e-04
		,3.9390848700e-04
		,3.9431834630e-04
		,3.9472288430e-04
		,3.9512251630e-04
		,3.9551749590e-04
		,3.9590800450e-04
		,3.9629418010e-04
		,3.9667611100e-04
		,3.9705380150e-04
		,3.9742710050e-04
		,3.9779559790e-04
		,3.9815874540e-04
		,3.9851668030e-04
		,3.9887052140e-04
		,3.9922128450e-04
		,3.9956945010e-04
		,3.9991519230e-04
		,4.0025856180e-04
		,4.0059955300e-04
		,4.0093810520e-04
		,4.0127405630e-04
		////////////////////////////////
		,-1.8589197280e-17
		,3.1268863230e-09
		,5.7790099980e-09
		,8.0988475080e-09
		,1.0198797970e-08
		,1.2172125880e-08
		,1.4096603060e-08
		,1.6037541310e-08
		,1.8050041430e-08
		,2.0180997010e-08
		,2.2471060860e-08
		,2.4954177290e-08
		,2.7653852370e-08
		,3.0579724940e-08
		,3.3739163920e-08
		,3.7160007660e-08
		,4.0886156350e-08
		,4.4958850730e-08
		,4.9409104400e-08
		,5.4254679880e-08
		,5.9491163990e-08
		,6.5078055760e-08
		,7.0942901370e-08
		,7.7031586140e-08
		,8.3359980920e-08
		,8.9980742320e-08
		,9.6924248360e-08
		,1.0419337230e-07
		,1.1180128120e-07
		,1.1981354060e-07
		,1.2833566360e-07
		,1.3747242810e-07
		,1.4730923370e-07
		,1.5791148400e-07
		,1.6932930430e-07
		,1.8160578690e-07
		,1.9478841500e-07
		,2.0893543620e-07
		,2.2410943640e-07
		,2.4036354080e-07
		,2.5773863020e-07
		,2.7629199440e-07
		,2.9612854370e-07
		,3.1738836250e-07
		,3.4022022630e-07
		,3.6477076370e-07
		,3.9118852710e-07
		,4.1963865020e-07
		,4.5031098230e-07
		,4.8341601250e-07
		,5.1918123720e-07
		,5.5785013360e-07
		,5.9968145240e-07
		,6.4494587180e-07
		,6.9391664710e-07
		,7.4684895600e-07
		,8.0394326370e-07
		,8.6530889320e-07
		,9.3100548450e-07
		,1.0012323830e-06
		,1.0764889050e-06
		,1.1574803290e-06
		,1.2449824660e-06
		,1.3398229260e-06
		,1.4429627720e-06
		,1.5556288920e-06
		,1.6792416340e-06
		,1.8153121800e-06
		,1.9651491600e-06
		,2.1295714510e-06
		,2.3090912780e-06
		,2.5063195860e-06
		,2.7255266660e-06
		,2.9746035700e-06
		,3.2629480600e-06
		,3.6016463980e-06
		,4.0020770100e-06
		,4.4783785530e-06
		,5.0476176260e-06
		,5.7285069750e-06
		,6.5400757280e-06
		,7.5130258570e-06
		,8.6794978020e-06
		,1.0076968470e-05
		,1.1748522070e-05
		,1.3742456860e-05
		,1.6110331320e-05
		,1.8888467310e-05
		,2.2141328010e-05
		,2.5903462300e-05
		,3.0220663450e-05
		,3.5183941790e-05
		,4.0858182630e-05
		,4.7287722340e-05
		,5.4466979080e-05
		,6.2251690850e-05
		,7.0336460060e-05
		,7.8776977940e-05
		,8.7348763370e-05
		,9.6557325760e-05
		,1.0661550640e-04
		,1.1760537680e-04
		,1.2954739600e-04
		,1.4244849310e-04
		,1.5630936490e-04
		,1.7112618640e-04
		,1.8689101220e-04
		,2.0359215290e-04
		,2.2121433190e-04
		,2.3973895010e-04
		,2.5914489380e-04
		,2.7940876350e-04
		,3.0050530370e-04
		,3.2240783790e-04
		,3.4508858720e-04
		,3.6840798330e-04
		,3.9207328470e-04
		,4.1638014900e-04
		,4.4129781250e-04
		,4.6679480780e-04
		,4.9283911580e-04
		////////////////////////////////
		,-1.3577953490e-18
		,1.1254322520e-08
		,2.1074658190e-08
		,2.9943494510e-08
		,3.8207736870e-08
		,4.6120778530e-08
		,5.3836323600e-08
		,6.1473169150e-08
		,6.9202047030e-08
		,7.7249958680e-08
		,8.5749533400e-08
		,9.4683198940e-08
		,1.0394895110e-07
		,1.1348796510e-07
		,1.2332173520e-07
		,1.3353578400e-07
		,1.4429069260e-07
		,1.5577384610e-07
		,1.6815446070e-07
		,1.8158070290e-07
		,1.9618575400e-07
		,2.1210281830e-07
		,2.2947109210e-07
		,2.4843427340e-07
		,2.6914384270e-07
		,2.9175295130e-07
		,3.1639182160e-07
		,3.4313598600e-07
		,3.7199136910e-07
		,4.0296601650e-07
		,4.3618430400e-07
		,4.7185738910e-07
		,5.1020156570e-07
		,5.5145185620e-07
		,5.9590813840e-07
		,6.4391034050e-07
		,6.9577217220e-07
		,7.5178610580e-07
		,8.1218683090e-07
		,8.7703498910e-07
		,9.4612154800e-07
		,1.0190467060e-06
		,1.0955884890e-06
		,1.1760226700e-06
		,1.2609272680e-06
		,1.3507667450e-06
		,1.4456432800e-06
		,1.5451735770e-06
		,1.6483870900e-06
		,1.7536895220e-06
		,1.8592384220e-06
		,1.9640179310e-06
		,2.0686933710e-06
		,2.1751365310e-06
		,2.2853876850e-06
		,2.4011263420e-06
		,2.5236240050e-06
		,2.6538435130e-06
		,2.7925364870e-06
		,2.9402991910e-06
		,3.0975978530e-06
		,3.2648220550e-06
		,3.4424375910e-06
		,3.6311673580e-06
		,3.8320026530e-06
		,4.0461180050e-06
		,4.2748121640e-06
		,4.5195277390e-06
		,4.7819133830e-06
		,5.0639135580e-06
		,5.3678781340e-06
		,5.6967001450e-06
		,6.0540037570e-06
		,6.4443865960e-06
		,6.8736889450e-06
		,7.3493396880e-06
		,7.8807543020e-06
		,8.4797828920e-06
		,9.1609100550e-06
		,9.9420314310e-06
		,1.0845299000e-05
		,1.1896453390e-05
		,1.3124106350e-05
		,1.4557609240e-05
		,1.6222275410e-05
		,1.8152642330e-05
		,2.0403454260e-05
		,2.3028406800e-05
		,2.6079327740e-05
		,2.9599467630e-05
		,3.3612752740e-05
		,3.8091367560e-05
		,4.2897476930e-05
		,4.8023811510e-05
		,5.3440784940e-05
		,5.9177517830e-05
		,6.5473407530e-05
		,7.2450450350e-05
		,8.0164439400e-05
		,8.8647525960e-05
		,9.7922611850e-05
		,1.0800199280e-04
		,1.1890303320e-04
		,1.3064045580e-04
		,1.4322174950e-04
		,1.5665093570e-04
		,1.7092862040e-04
		,1.8605210470e-04
		,2.0201551560e-04
		,2.1881007500e-04
		,2.3642435280e-04
		,2.5484443740e-04
		,2.7405413170e-04
		,2.9403556880e-04
		,3.1476899690e-04
		,3.3623309390e-04
		,3.5839724510e-04
		,3.8123987670e-04
		,4.0427202990e-04
		,4.2774725060e-04
		,4.5177058200e-04
		////////////////////////////////
		,-4.2819120410e-18
		,4.4258121360e-08
		,8.1570018910e-08
		,1.1396121430e-07
		,1.4327180410e-07
		,1.7100477990e-07
		,1.9834484340e-07
		,2.2619070650e-07
		,2.5514741270e-07
		,2.8561248440e-07
		,3.1786888440e-07
		,3.5177096990e-07
		,3.8723541700e-07
		,4.2454549490e-07
		,4.6444339190e-07
		,5.0756306300e-07
		,5.5422004480e-07
		,6.0451273880e-07
		,6.5877688830e-07
		,7.1785133220e-07
		,7.8263209750e-07
		,8.5368371350e-07
		,9.3122120770e-07
		,1.0150654490e-06
		,1.1043014310e-06
		,1.1971026280e-06
		,1.2916053170e-06
		,1.3872053100e-06
		,1.4844072350e-06
		,1.5837550840e-06
		,1.6854355950e-06
		,1.7897432950e-06
		,1.8976944880e-06
		,2.0108307910e-06
		,2.1305691390e-06
		,2.2579892660e-06
		,2.3940107510e-06
		,2.5395017560e-06
		,2.6952124960e-06
		,2.8617702430e-06
		,3.0398687470e-06
		,3.2300633970e-06
		,3.4325749490e-06
		,3.6473525810e-06
		,3.8743526800e-06
		,4.1138429400e-06
		,4.3664373950e-06
		,4.6330530530e-06
		,4.9148151260e-06
		,5.2128728400e-06
		,5.5282173900e-06
		,5.8615113140e-06
		,6.2130227400e-06
		,6.5828230780e-06
		,6.9712412970e-06
		,7.3791551310e-06
		,7.8077808700e-06
		,8.2582496780e-06
		,8.7313293540e-06
		,9.2273352330e-06
		,9.7461547210e-06
		,1.0287234930e-05
		,1.0849563520e-05
		,1.1432285380e-05
		,1.2035744910e-05
		,1.2661726250e-05
		,1.3312710260e-05
		,1.3991121110e-05
		,1.4698992520e-05
		,1.5437856590e-05
		,1.6208761720e-05
		,1.7012175860e-05
		,1.7847787010e-05
		,1.8714200270e-05
		,1.9608525510e-05
		,2.0526050260e-05
		,2.1460552360e-05
		,2.2406017770e-05
		,2.3359811700e-05
		,2.4325675810e-05
		,2.5312939900e-05
		,2.6333266150e-05
		,2.7399134380e-05
		,2.8524896830e-05
		,2.9731840470e-05
		,3.1048261480e-05
		,3.2509212360e-05
		,3.4153791980e-05
		,3.6023985860e-05
		,3.8163967230e-05
		,4.0619470110e-05
		,4.3436984160e-05
		,4.6661382140e-05
		,5.0337683460e-05
		,5.4509612170e-05
		,5.9216297950e-05
		,6.4492794900e-05
		,7.0373452880e-05
		,7.6887364770e-05
		,8.4053941960e-05
		,9.1902011190e-05
		,1.0045224680e-04
		,1.0972097580e-04
		,1.1972121000e-04
		,1.3046258980e-04
		,1.4195124660e-04
		,1.5418955830e-04
		,1.6717582050e-04
		,1.8090727290e-04
		,1.9537579850e-04
		,2.1056997720e-04
		,2.2648207660e-04
		,2.4310559870e-04
		,2.6043572790e-04
		,2.7846614170e-04
		,2.9718738070e-04
		,3.1658642070e-04
		,3.3664678750e-04
		,3.5734839870e-04
		,3.7866858150e-04
		,4.0061875880e-04
		////////////////////////////////
		,-2.0888245240e-18
		,1.9013048250e-07
		,3.5426077550e-07
		,4.9904370440e-07
		,6.3062642340e-07
		,7.5494889370e-07
		,8.7651604920e-07
		,9.9852389330e-07
		,1.1238549970e-06
		,1.2547060330e-06
		,1.3912360170e-06
		,1.5309453880e-06
		,1.6712929120e-06
		,1.8141841590e-06
		,1.9636037160e-06
		,2.1221368730e-06
		,2.2906338580e-06
		,2.4677484640e-06
		,2.6487299640e-06
		,2.8361861500e-06
		,3.0388998080e-06
		,3.2599177460e-06
		,3.5003063120e-06
		,3.7601828630e-06
		,4.0389227400e-06
		,4.3353613020e-06
		,4.6481897980e-06
		,4.9782429170e-06
		,5.3291731750e-06
		,5.7047115340e-06
		,6.1073725340e-06
		,6.5388315710e-06
		,6.9999744080e-06
		,7.4906255260e-06
		,8.0094557490e-06
		,8.5538035870e-06
		,9.1193071930e-06
		,9.7000276430e-06
		,1.0289842780e-05
		,1.0885752800e-05
		,1.1490228830e-05
		,1.2109200160e-05
		,1.2748613920e-05
		,1.3412498860e-05
		,1.4102386490e-05
		,1.4818576150e-05
		,1.5559195780e-05
		,1.6318738010e-05
		,1.7089403290e-05
		,1.7864256970e-05
		,1.8640196850e-05
		,1.9417786010e-05
		,2.0198855460e-05
		,2.0985242910e-05
		,2.1779413230e-05
		,2.2585028010e-05
		,2.3406231160e-05
		,2.4246506180e-05
		,2.5107825720e-05
		,2.5990246320e-05
		,2.6892596370e-05
		,2.7814380080e-05
		,2.8757064170e-05
		,2.9723195310e-05
		,3.0714670830e-05
		,3.1732032280e-05
		,3.2775058910e-05
		,3.3843384300e-05
		,3.4937260130e-05
		,3.6057906790e-05
		,3.7206934630e-05
		,3.8385685240e-05
		,3.9595117340e-05
		,4.0836120160e-05
		,4.2109791640e-05
		,4.3417491750e-05
		,4.4760747440e-05
		,4.6140965210e-05
		,4.7559499030e-05
		,4.9017778680e-05
		,5.0517407540e-05
		,5.2060211550e-05
		,5.3648293770e-05
		,5.5284132140e-05
		,5.6970688680e-05
		,5.8711228100e-05
		,6.0508873450e-05
		,6.2370336070e-05
		,6.4304342320e-05
		,6.6321331570e-05
		,6.8434962160e-05
		,7.0663488790e-05
		,7.3030495900e-05
		,7.5565692900e-05
		,7.8304974400e-05
		,8.1289964740e-05
		,8.4567211180e-05
		,8.8187017000e-05
		,9.2201889980e-05
		,9.6664658420e-05
		,1.0162641430e-04
		,1.0713452030e-04
		,1.1323091420e-04
		,1.1995085870e-04
		,1.2732218630e-04
		,1.3536498030e-04
		,1.4409156690e-04
		,1.5350668420e-04
		,1.6360842290e-04
		,1.7438808920e-04
		,1.8583168050e-04
		,1.9792793570e-04
		,2.1072542140e-04
		,2.2415786710e-04
		,2.3823742520e-04
		,2.5294832100e-04
		,2.6828239490e-04
		,2.8422673840e-04
		,3.0082138920e-04
		,3.1797308080e-04
		,3.3563865700e-04
		////////////////////////////////
		,2.2035138170e-17
		,8.4800856740e-07
		,1.5755815410e-06
		,2.2133975630e-06
		,2.8019870210e-06
		,3.3726602860e-06
		,3.9447202170e-06
		,4.5246496970e-06
		,5.1107179000e-06
		,5.7067570720e-06
		,6.3232947830e-06
		,6.9642901000e-06
		,7.6191434810e-06
		,8.2716841360e-06
		,8.9232167330e-06
		,9.5913856830e-06
		,1.0290128110e-05
		,1.1024282580e-05
		,1.1790234270e-05
		,1.2580299030e-05
		,1.3393507940e-05
		,1.4235858680e-05
		,1.5105132760e-05
		,1.5987649790e-05
		,1.6888091950e-05
		,1.7799747790e-05
		,1.8710978110e-05
		,1.9629833420e-05
		,2.0550185730e-05
		,2.1471882380e-05
		,2.2401160780e-05
		,2.3347176310e-05
		,2.4320059380e-05
		,2.5328580710e-05
		,2.6379509690e-05
		,2.7478368900e-05
		,2.8629640820e-05
		,2.9835919840e-05
		,3.1096686390e-05
		,3.2407896290e-05
		,3.3764353700e-05
		,3.5162808080e-05
		,3.6601394280e-05
		,3.8077175900e-05
		,3.9584457780e-05
		,4.1114197820e-05
		,4.2654886750e-05
		,4.4195526640e-05
		,4.5728519240e-05
		,4.7251730190e-05
		,4.8772917020e-05
		,5.0301918730e-05
		,5.1845818210e-05
		,5.3410777270e-05
		,5.5002636720e-05
		,5.6626097160e-05
		,5.8284261910e-05
		,5.9979112120e-05
		,6.1712279410e-05
		,6.3485415240e-05
		,6.5300090540e-05
		,6.7157575340e-05
		,6.9058689320e-05
		,7.1003707260e-05
		,7.2992216040e-05
		,7.5022846510e-05
		,7.7092893970e-05
		,7.9197842780e-05
		,8.1330721790e-05
		,8.3481461970e-05
		,8.5638335070e-05
		,8.7790938340e-05
		,8.9930427650e-05
		,9.2051347990e-05
		,9.4153096970e-05
		,9.6238670310e-05
		,9.8312108110e-05
		,1.0037632620e-04
		,1.0243209590e-04
		,1.0447854630e-04
		,1.0651523790e-04
		,1.0854386750e-04
		,1.1056793890e-04
		,1.1259106280e-04
		,1.1461554440e-04
		,1.1664235880e-04
		,1.1867223550e-04
		,1.2070665940e-04
		,1.2274783810e-04
		,1.2479792050e-04
		,1.2685845810e-04
		,1.2893008200e-04
		,1.3101015270e-04
		,1.3309887470e-04
		,1.3520421060e-04
		,1.3733235740e-04
		,1.3949087580e-04
		,1.4169024710e-04
		,1.4394487180e-04
		,1.4627320190e-04
		,1.4869775640e-04
		,1.5124504200e-04
		,1.5394556580e-04
		,1.5683382780e-04
		,1.5994862600e-04
		,1.6333263440e-04
		,1.6702981400e-04
		,1.7108615830e-04
		,1.7554740640e-04
		,1.8045730980e-04
		,1.8585626650e-04
		,1.9178367250e-04
		,1.9828199240e-04
		,2.0537729460e-04
		,2.1310330710e-04
		,2.2149280340e-04
		,2.3057515930e-04
		,2.4037448580e-04
		,2.5090918450e-04
		,2.6219253430e-04
		,2.7423372410e-04
		////////////////////////////////
		,-4.2296956750e-18
		,2.8402525580e-06
		,5.5182143350e-06
		,8.0624942870e-06
		,1.0505267920e-05
		,1.2854315610e-05
		,1.5055094550e-05
		,1.7156815960e-05
		,1.9259022000e-05
		,2.1397087970e-05
		,2.3567674270e-05
		,2.5758338150e-05
		,2.7961522230e-05
		,3.0154088820e-05
		,3.2309105600e-05
		,3.4434219270e-05
		,3.6556100050e-05
		,3.8692945310e-05
		,4.0832294110e-05
		,4.2935416440e-05
		,4.5008459570e-05
		,4.7118083580e-05
		,4.9301877220e-05
		,5.1569785450e-05
		,5.3920253170e-05
		,5.6328842720e-05
		,5.8708149740e-05
		,6.0927093620e-05
		,6.2999687680e-05
		,6.5003799510e-05
		,6.6964827590e-05
		,6.8858336030e-05
		,7.0629724290e-05
		,7.2365291590e-05
		,7.4114115190e-05
		,7.5887831490e-05
		,7.7698583590e-05
		,7.9562890660e-05
		,8.1488730370e-05
		,8.3475329670e-05
		,8.5521424670e-05
		,8.7628488730e-05
		,8.9798268230e-05
		,9.2024619170e-05
		,9.4285784730e-05
		,9.6543116640e-05
		,9.8756067700e-05
		,1.0090412800e-04
		,1.0299206280e-04
		,1.0503848180e-04
		,1.0706353910e-04
		,1.0908271190e-04
		,1.1110374760e-04
		,1.1312630060e-04
		,1.1515980060e-04
		,1.1722147040e-04
		,1.1931900680e-04
		,1.2145238490e-04
		,1.2361627270e-04
		,1.2580255370e-04
		,1.2800452350e-04
		,1.3021836880e-04
		,1.3244024240e-04
		,1.3466356990e-04
		,1.3687990140e-04
		,1.3908277290e-04
		,1.4126991700e-04
		,1.4344096810e-04
		,1.4559510490e-04
		,1.4773208900e-04
		,1.4985382420e-04
		,1.5196338590e-04
		,1.5406339860e-04
		,1.5615555980e-04
		,1.5824123170e-04
		,1.6032528520e-04
		,1.6241533070e-04
		,1.6451782130e-04
		,1.6663825340e-04
		,1.6878156370e-04
		,1.7095201690e-04
		,1.7315306120e-04
		,1.7538717300e-04
		,1.7765570950e-04
		,1.7995920130e-04
		,1.8229788330e-04
		,1.8467109490e-04
		,1.8707674840e-04
		,1.8951138980e-04
		,1.9197061300e-04
		,1.9444976310e-04
		,1.9694465920e-04
		,1.9945188120e-04
		,2.0196839200e-04
		,2.0449078660e-04
		,2.0701463380e-04
		,2.0953423290e-04
		,2.1204245960e-04
		,2.1452686680e-04
		,2.1697520900e-04
		,2.1939796080e-04
		,2.2180023520e-04
		,2.2418317620e-04
		,2.2654866160e-04
		,2.2890145060e-04
		,2.3125034170e-04
		,2.3360792710e-04
		,2.3599069510e-04
		,2.3841947230e-04
		,2.4092078910e-04
		,2.4352679270e-04
		,2.4627515140e-04
		,2.4920803550e-04
		,2.5237243760e-04
		,2.5581925260e-04
		,2.5960167200e-04
		,2.6377385660e-04
		,2.6838985650e-04
		,2.7350176790e-04
		,2.7915828740e-04
		,2.8540383800e-04
		////////////////////////////////
		,-1.0547876380e-17
		,5.9114853410e-06
		,1.1469040560e-05
		,1.6708416830e-05
		,2.1717859300e-05
		,2.6559087320e-05
		,3.1220212270e-05
		,3.5698229110e-05
		,3.9939327170e-05
		,4.3767724910e-05
		,4.7298608450e-05
		,5.0739037900e-05
		,5.4164779520e-05
		,5.7592696830e-05
		,6.1017165530e-05
		,6.4433498440e-05
		,6.7825834350e-05
		,7.1143236180e-05
		,7.4394887420e-05
		,7.7632428070e-05
		,8.0876028090e-05
		,8.4125864300e-05
		,8.7373523140e-05
		,9.0606204720e-05
		,9.3810597160e-05
		,9.6979117600e-05
		,1.0011447200e-04
		,1.0322233340e-04
		,1.0629881750e-04
		,1.0932172620e-04
		,1.1223439160e-04
		,1.1496520730e-04
		,1.1756903850e-04
		,1.2010485110e-04
		,1.2257580860e-04
		,1.2501974400e-04
		,1.2744368570e-04
		,1.2976484630e-04
		,1.3190945620e-04
		,1.3402888400e-04
		,1.3617085240e-04
		,1.3833482990e-04
		,1.4052030280e-04
		,1.4272514110e-04
		,1.4494322630e-04
		,1.4716601940e-04
		,1.4938522540e-04
		,1.5159565470e-04
		,1.5379848090e-04
		,1.5599900800e-04
		,1.5819999650e-04
		,1.6040861440e-04
		,1.6263459270e-04
		,1.6488082610e-04
		,1.6714718250e-04
		,1.6943240030e-04
		,1.7172916720e-04
		,1.7401945030e-04
		,1.7630273870e-04
		,1.7859939750e-04
		,1.8091948860e-04
		,1.8326532660e-04
		,1.8563727440e-04
		,1.8803488200e-04
		,1.9045664720e-04
		,1.9290004640e-04
		,1.9536159770e-04
		,1.9783690770e-04
		,2.0032099650e-04
		,2.0280917190e-04
		,2.0529811610e-04
		,2.0778685940e-04
		,2.1027767690e-04
		,2.1277570770e-04
		,2.1528662430e-04
		,2.1781474680e-04
		,2.2036308970e-04
		,2.2293324410e-04
		,2.2552364360e-04
		,2.2813354160e-04
		,2.3076778960e-04
		,2.3343026830e-04
		,2.3612213870e-04
		,2.3884331380e-04
		,2.4159289920e-04
		,2.4436911840e-04
		,2.4716911870e-04
		,2.4998858630e-04
		,2.5282158990e-04
		,2.5566121250e-04
		,2.5849913440e-04
		,2.6132420690e-04
		,2.6412311300e-04
		,2.6688393200e-04
		,2.6960102340e-04
		,2.7227779110e-04
		,2.7492563950e-04
		,2.7755982220e-04
		,2.8019500810e-04
		,2.8284313900e-04
		,2.8551314720e-04
		,2.8821138720e-04
		,2.9094212080e-04
		,2.9370711070e-04
		,2.9649942430e-04
		,2.9929881730e-04
		,3.0212007320e-04
		,3.0497731410e-04
		,3.0787422580e-04
		,3.1081309160e-04
		,3.1379654060e-04
		,3.1682801550e-04
		,3.1991203890e-04
		,3.2305443840e-04
		,3.2626255170e-04
		,3.2954539800e-04
		,3.3291379160e-04
		,3.3638038550e-04
		,3.3995966810e-04
		,3.4366801650e-04
		,3.4752379450e-04
		////////////////////////////////
		,-1.5144444630e-18
		,7.8349141720e-06
		,1.5365730660e-05
		,2.2643308400e-05
		,2.9721064680e-05
		,3.6645960290e-05
		,4.3451730800e-05
		,5.0150991020e-05
		,5.6716265600e-05
		,6.3032138980e-05
		,6.8948790560e-05
		,7.4523963570e-05
		,7.9876721200e-05
		,8.5033252950e-05
		,8.9975770440e-05
		,9.4699430900e-05
		,9.9185282120e-05
		,1.0341312060e-04
		,1.0748607790e-04
		,1.1153448910e-04
		,1.1561336540e-04
		,1.1973419690e-04
		,1.2389408620e-04
		,1.2808574530e-04
		,1.3230002230e-04
		,1.3652563600e-04
		,1.4074627480e-04
		,1.4493562820e-04
		,1.4906935800e-04
		,1.5312080680e-04
		,1.5703893940e-04
		,1.6074862670e-04
		,1.6424002730e-04
		,1.6751762660e-04
		,1.7053520680e-04
		,1.7340405240e-04
		,1.7624325800e-04
		,1.7908318610e-04
		,1.8192181560e-04
		,1.8474979940e-04
		,1.8755759830e-04
		,1.9033355870e-04
		,1.9302021500e-04
		,1.9544393480e-04
		,1.9772056220e-04
		,2.0000698300e-04
		,2.0231422640e-04
		,2.0463558590e-04
		,2.0696481560e-04
		,2.0929222980e-04
		,2.1159784770e-04
		,2.1386690100e-04
		,2.1612189610e-04
		,2.1838420990e-04
		,2.2065972160e-04
		,2.2294842380e-04
		,2.2524902240e-04
		,2.2756065140e-04
		,2.2988156500e-04
		,2.3220562520e-04
		,2.3451559200e-04
		,2.3678114290e-04
		,2.3900365320e-04
		,2.4121626670e-04
		,2.4343542270e-04
		,2.4566499830e-04
		,2.4790584040e-04
		,2.5015756210e-04
		,2.5241859820e-04
		,2.5468715660e-04
		,2.5696548280e-04
		,2.5925575340e-04
		,2.6155829100e-04
		,2.6387291150e-04
		,2.6619938910e-04
		,2.6853760910e-04
		,2.7088762660e-04
		,2.7324954260e-04
		,2.7562312210e-04
		,2.7800749690e-04
		,2.8040103310e-04
		,2.8280049140e-04
		,2.8519917200e-04
		,2.8759102970e-04
		,2.8998023270e-04
		,2.9237340810e-04
		,2.9477354830e-04
		,2.9718181200e-04
		,2.9959883160e-04
		,3.0202466020e-04
		,3.0445850110e-04
		,3.0689898990e-04
		,3.0934441030e-04
		,3.1179386730e-04
		,3.1424869310e-04
		,3.1671100970e-04
		,3.1918237220e-04
		,3.2166381750e-04
		,3.2415608870e-04
		,3.2665965250e-04
		,3.2917448650e-04
		,3.3170012430e-04
		,3.3423608350e-04
		,3.3678202220e-04
		,3.3933772800e-04
		,3.4190312390e-04
		,3.4447828940e-04
		,3.4706339810e-04
		,3.4965836930e-04
		,3.5226200460e-04
		,3.5486875460e-04
		,3.5745531850e-04
		,3.6001371540e-04
		,3.6256798540e-04
		,3.6512419580e-04
		,3.6768294190e-04
		,3.7024464390e-04
		,3.7281068750e-04
		,3.7538399570e-04
		,3.7796937440e-04
		,3.8057352160e-04
		////////////////////////////////
		,5.1170344600e-18
		,9.5217399130e-06
		,1.8678995080e-05
		,2.7528942880e-05
		,3.6128463270e-05
		,4.4527816230e-05
		,5.2761236660e-05
		,6.0825035890e-05
		,6.8634147120e-05
		,7.6050406270e-05
		,8.3098681140e-05
		,8.9908368610e-05
		,9.6550251240e-05
		,1.0305178840e-04
		,1.0941688040e-04
		,1.1563587330e-04
		,1.2169714040e-04
		,1.2759304990e-04
		,1.3332504170e-04
		,1.3891120880e-04
		,1.4437981070e-04
		,1.4975463870e-04
		,1.5504916320e-04
		,1.6026673880e-04
		,1.6540063590e-04
		,1.7043220640e-04
		,1.7533027230e-04
		,1.8006769300e-04
		,1.8466543180e-04
		,1.8919087980e-04
		,1.9369974780e-04
		,1.9821565060e-04
		,2.0273517870e-04
		,2.0722496880e-04
		,2.1161630230e-04
		,2.1585640530e-04
		,2.1997418820e-04
		,2.2401849050e-04
		,2.2801105910e-04
		,2.3195263840e-04
		,2.3582471840e-04
		,2.3960997630e-04
		,2.4332232860e-04
		,2.4695517440e-04
		,2.5047438390e-04
		,2.5385065080e-04
		,2.5710078910e-04
		,2.6014207870e-04
		,2.6274591020e-04
		,2.6521110540e-04
		,2.6772599050e-04
		,2.7029024240e-04
		,2.7288621630e-04
		,2.7550019530e-04
		,2.7812336050e-04
		,2.8075073930e-04
		,2.8337963320e-04
		,2.8600838320e-04
		,2.8863577060e-04
		,2.9126069900e-04
		,2.9388184430e-04
		,2.9649702150e-04
		,2.9910152810e-04
		,3.0168293260e-04
		,3.0421033060e-04
		,3.0664618260e-04
		,3.0900339770e-04
		,3.1131497750e-04
		,3.1358803000e-04
		,3.1583060610e-04
		,3.1806578010e-04
		,3.2030625510e-04
		,3.2255475400e-04
		,3.2481083450e-04
		,3.2707343100e-04
		,3.2934162300e-04
		,3.3161469760e-04
		,3.3389186970e-04
		,3.3617222250e-04
		,3.3845455570e-04
		,3.4073748040e-04
		,3.4302206570e-04
		,3.4530896390e-04
		,3.4759777640e-04
		,3.4988713310e-04
		,3.5217334860e-04
		,3.5444743600e-04
		,3.5669723650e-04
		,3.5892490120e-04
		,3.6114638040e-04
		,3.6337149790e-04
		,3.6560337930e-04
		,3.6784265130e-04
		,3.7008788610e-04
		,3.7233645740e-04
		,3.7458517120e-04
		,3.7682981610e-04
		,3.7906669120e-04
		,3.8129639900e-04
		,3.8352256740e-04
		,3.8574814580e-04
		,3.8797469710e-04
		,3.9020269370e-04
		,3.9243191570e-04
		,3.9466204310e-04
		,3.9689308680e-04
		,3.9912500280e-04
		,4.0135722550e-04
		,4.0358939590e-04
		,4.0582151270e-04
		,4.0805376900e-04
		,4.1028648780e-04
		,4.1252010090e-04
		,4.1475513820e-04
		,4.1699220280e-04
		,4.1923157940e-04
		,4.2147058280e-04
		,4.2369074730e-04
		,4.2586234630e-04
		,4.2801195810e-04
		,4.3015585390e-04
		////////////////////////////////
		,-3.7075319920e-18
		,1.8616075440e-14
		,3.1802484090e-14
		,4.1221272820e-14
		,4.8022193860e-14
		,5.3014600950e-14
		,5.6757209230e-14
		,5.9611982590e-14
		,6.1880940490e-14
		,6.3724387200e-14
		,6.5301739290e-14
		,6.6660879170e-14
		,6.7900809080e-14
		,6.8979181540e-14
		,7.0025963100e-14
		,7.1028360740e-14
		,7.1947316630e-14
		,7.2892276270e-14
		,7.3768101430e-14
		,7.4614215480e-14
		,7.5435109030e-14
		,7.6264983790e-14
		,7.7063163210e-14
		,7.7847139780e-14
		,7.8555715920e-14
		,7.9326481750e-14
		,8.0020385080e-14
		,8.0712251980e-14
		,8.1438947190e-14
		,8.2135356910e-14
		,8.2797669340e-14
		,8.3462853670e-14
		,8.4126053780e-14
		,8.4816980780e-14
		,8.5473236110e-14
		,8.6150534640e-14
		,8.6794780210e-14
		,8.7474062960e-14
		,8.8142014760e-14
		,8.8826675790e-14
		,8.9512590020e-14
		,9.0204509140e-14
		,9.0847136000e-14
		,9.1584744430e-14
		,9.2273217260e-14
		,9.2999703610e-14
		,9.3709898450e-14
		,9.4413305160e-14
		,9.5135300910e-14
		,9.5853537070e-14
		,9.6592137610e-14
		,9.7311888050e-14
		,9.8061036300e-14
		,9.8794571860e-14
		,9.9547688560e-14
		,1.0030158850e-13
		,1.0106838590e-13
		,1.0183612320e-13
		,1.0263216170e-13
		,1.0337723710e-13
		,1.0423901610e-13
		,1.0505876080e-13
		,1.0590320400e-13
		,1.0676101450e-13
		,1.0760394330e-13
		,1.0850994960e-13
		,1.0942196070e-13
		,1.1044216410e-13
		,1.1146346410e-13
		,1.1255509950e-13
		,1.1374140320e-13
		,1.1504503710e-13
		,1.1655456010e-13
		,1.1811859700e-13
		,1.2008929500e-13
		,1.2236117700e-13
		,1.2512154320e-13
		,1.2847989120e-13
		,1.3260540210e-13
		,1.3785293840e-13
		,1.4453987110e-13
		,1.5310983050e-13
		,1.6430423690e-13
		,1.7897494810e-13
		,1.9784599620e-13
		,2.1960596720e-13
		,2.4703021330e-13
		,2.8244742800e-13
		,3.2846639320e-13
		,3.8834561940e-13
		,4.6667194890e-13
		,5.6945297970e-13
		,7.0503199980e-13
		,8.8453798850e-13
		,1.1229525530e-12
		,1.4376850490e-12
		,1.8233616290e-12
		,2.3251135270e-12
		,2.9786622760e-12
		,3.8305027920e-12
		,4.9417682770e-12
		,6.3897200570e-12
		,8.2752881960e-12
		,1.0738402800e-11
		,1.3959646300e-11
		,1.8175476030e-11
		,2.3696497990e-11
		,3.0931674060e-11
		,4.0419354610e-11
		,5.2868290020e-11
		,6.9212471240e-11
		,9.0682937460e-11
		,1.1890323740e-10
		,1.5601520850e-10
		,2.0484585110e-10
		,2.6909792980e-10
		,3.5369404650e-10
		,4.6515437330e-10
		,6.1208026560e-10
		,8.0584630240e-10
		,1.0615014110e-09
		////////////////////////////////
		,3.2635061180e-17
		,1.2234830300e-05
		,2.4092528880e-05
		,3.5583565250e-05
		,4.6709409850e-05
		,5.7447692070e-05
		,6.7745930070e-05
		,7.7576975050e-05
		,8.6996532810e-05
		,9.6086529150e-05
		,1.0490322810e-04
		,1.1346518370e-04
		,1.2174665800e-04
		,1.2974504510e-04
		,1.3752815450e-04
		,1.4514954920e-04
		,1.5263895620e-04
		,1.6001498150e-04
		,1.6729021060e-04
		,1.7447323600e-04
		,1.8156981610e-04
		,1.8858380630e-04
		,1.9551794840e-04
		,2.0237436780e-04
		,2.0915470550e-04
		,2.1586001580e-04
		,2.2249062090e-04
		,2.2904599870e-04
		,2.3552461650e-04
		,2.4192341200e-04
		,2.4823636450e-04
		,2.5445173450e-04
		,2.6055045330e-04
		,2.6651577620e-04
		,2.7235205070e-04
		,2.7808035710e-04
		,2.8372061420e-04
		,2.8928624000e-04
		,2.9478551900e-04
		,3.0022325160e-04
		,3.0560181440e-04
		,3.1092174690e-04
		,3.1618197700e-04
		,3.2137974320e-04
		,3.2651022220e-04
		,3.3156586160e-04
		,3.3653561690e-04
		,3.4140498020e-04
		,3.4615825520e-04
		,3.5078195280e-04
		,3.5526545530e-04
		,3.5960125620e-04
		,3.6378466370e-04
		,3.6779698100e-04
		,3.7153247390e-04
		,3.7467774330e-04
		,3.7737910800e-04
		,3.8008111490e-04
		,3.8284068130e-04
		,3.8563386320e-04
		,3.8843878250e-04
		,3.9124016220e-04
		,3.9402710950e-04
		,3.9679083340e-04
		,3.9952159120e-04
		,4.0220108880e-04
		,4.0479677810e-04
		,4.0731317980e-04
		,4.0978587270e-04
		,4.1222793080e-04
		,4.1463930350e-04
		,4.1701629340e-04
		,4.1935396240e-04
		,4.2164755400e-04
		,4.2389819850e-04
		,4.2611419170e-04
		,4.2830347990e-04
		,4.3047035890e-04
		,4.3261674510e-04
		,4.3474348960e-04
		,4.3685100490e-04
		,4.3893954370e-04
		,4.4100934650e-04
		,4.4306071660e-04
		,4.4509400900e-04
		,4.4710956780e-04
		,4.4910768640e-04
		,4.5108860870e-04
		,4.5305254100e-04
		,4.5499965300e-04
		,4.5693005640e-04
		,4.5884374230e-04
		,4.6074042080e-04
		,4.6261912620e-04
		,4.6447741560e-04
		,4.6631118810e-04
		,4.6811925740e-04
		,4.6990742730e-04
		,4.7168188270e-04
		,4.7344539960e-04
		,4.7519868030e-04
		,4.7694145010e-04
		,4.7867280110e-04
		,4.8039197260e-04
		,4.8209836290e-04
		,4.8378873250e-04
		,4.8545615300e-04
		,4.8709364900e-04
		,4.8869925280e-04
		,4.9027135610e-04
		,4.9182468100e-04
		,4.9337158150e-04
		,4.9491469030e-04
		,4.9645471850e-04
		,4.9799151540e-04
		,4.9952423500e-04
		,5.0105189260e-04
		,5.0257371300e-04
		,5.0408915570e-04
		,5.0559786250e-04
		,5.0709962000e-04
		////////////////////////////////
		,-2.2244343150e-17
		,1.3273705690e-05
		,2.6132215450e-05
		,3.8559847880e-05
		,5.0525878840e-05
		,6.1997984130e-05
		,7.2980619530e-05
		,8.3520501420e-05
		,9.3676847960e-05
		,1.0350341970e-04
		,1.1304479300e-04
		,1.2233752820e-04
		,1.3141187870e-04
		,1.4029289840e-04
		,1.4900088450e-04
		,1.5755102150e-04
		,1.6595132440e-04
		,1.7419571110e-04
		,1.8224843930e-04
		,1.9006300810e-04
		,1.9767268660e-04
		,2.0514406140e-04
		,2.1251379240e-04
		,2.1979965370e-04
		,2.2701167790e-04
		,2.3415613470e-04
		,2.4123683310e-04
		,2.4825534970e-04
		,2.5521050700e-04
		,2.6209702300e-04
		,2.6890385040e-04
		,2.7561609530e-04
		,2.8222601310e-04
		,2.8874092140e-04
		,2.9517303670e-04
		,3.0152905210e-04
		,3.0780908050e-04
		,3.1400804060e-04
		,3.2011565710e-04
		,3.2611457320e-04
		,3.3197744740e-04
		,3.3766799920e-04
		,3.4315692330e-04
		,3.4844764570e-04
		,3.5357564070e-04
		,3.5858185760e-04
		,3.6349677300e-04
		,3.6833961510e-04
		,3.7312171850e-04
		,3.7784929060e-04
		,3.8252507010e-04
		,3.8714917500e-04
		,3.9171934400e-04
		,3.9623049110e-04
		,4.0067292510e-04
		,4.0502673080e-04
		,4.0924175400e-04
		,4.1315517670e-04
		,4.1638463590e-04
		,4.1916897260e-04
		,4.2199218020e-04
		,4.2489038770e-04
		,4.2783130240e-04
		,4.3079060880e-04
		,4.3375197780e-04
		,4.3670391530e-04
		,4.3963794840e-04
		,4.4254762780e-04
		,4.4542793890e-04
		,4.4827494010e-04
		,4.5108555790e-04
		,4.5385751860e-04
		,4.5658930820e-04
		,4.5927980470e-04
		,4.6192763080e-04
		,4.6453070690e-04
		,4.6708540790e-04
		,4.6958321650e-04
		,4.7200094920e-04
		,4.7430944030e-04
		,4.7653230360e-04
		,4.7870440770e-04
		,4.8083828950e-04
		,4.8293733600e-04
		,4.8500211970e-04
		,4.8703193780e-04
		,4.8902500520e-04
		,4.9097885270e-04
		,4.9289286340e-04
		,4.9477099790e-04
		,4.9661899210e-04
		,4.9844075490e-04
		,5.0023825140e-04
		,5.0201239060e-04
		,5.0376357780e-04
		,5.0549195140e-04
		,5.0719743520e-04
		,5.0887962950e-04
		,5.1053747220e-04
		,5.1216865100e-04
		,5.1376957200e-04
		,5.1533859990e-04
		,5.1688007340e-04
		,5.1840019930e-04
		,5.1990247320e-04
		,5.2138811290e-04
		,5.2285730500e-04
		,5.2430978210e-04
		,5.2574493500e-04
		,5.2716161960e-04
		,5.2855766620e-04
		,5.2992940830e-04
		,5.3127283890e-04
		,5.3258711730e-04
		,5.3387530630e-04
		,5.3514114130e-04
		,5.3638723000e-04
		,5.3761521710e-04
		,5.3882631740e-04
		,5.4002135870e-04
		,5.4120052580e-04
		////////////////////////////////
		,-4.1303318010e-17
		,1.4133930700e-05
		,2.7797671090e-05
		,4.0968424920e-05
		,5.3635735940e-05
		,6.5811965420e-05
		,7.7528304710e-05
		,8.8824942750e-05
		,9.9742598800e-05
		,1.1031871120e-04
		,1.2058695040e-04
		,1.3057785110e-04
		,1.4031914430e-04
		,1.4983578540e-04
		,1.5915013500e-04
		,1.6828208180e-04
		,1.7724917190e-04
		,1.8606675450e-04
		,1.9474810780e-04
		,2.0330447550e-04
		,2.1174491360e-04
		,2.2007574760e-04
		,2.2829909700e-04
		,2.3640891440e-04
		,2.4438134940e-04
		,2.5216704390e-04
		,2.5974058490e-04
		,2.6715032410e-04
		,2.7444570360e-04
		,2.8164349750e-04
		,2.8874284590e-04
		,2.9574199500e-04
		,3.0264356860e-04
		,3.0944556660e-04
		,3.1613166700e-04
		,3.2266681470e-04
		,3.2900630960e-04
		,3.3513104150e-04
		,3.4106972080e-04
		,3.4686951330e-04
		,3.5256694550e-04
		,3.5818434030e-04
		,3.6373463880e-04
		,3.6922537310e-04
		,3.7466092530e-04
		,3.8004372790e-04
		,3.8537490210e-04
		,3.9065460170e-04
		,3.9588219700e-04
		,4.0105637390e-04
		,4.0617519100e-04
		,4.1123611750e-04
		,4.1623604430e-04
		,4.2117121500e-04
		,4.2603694260e-04
		,4.3082685110e-04
		,4.3553103380e-04
		,4.4013123430e-04
		,4.4458558100e-04
		,4.4876763240e-04
		,4.5227503760e-04
		,4.5505938150e-04
		,4.5788522980e-04
		,4.6085583870e-04
		,4.6390651930e-04
		,4.6699040980e-04
		,4.7007779070e-04
		,4.7314875930e-04
		,4.7618897160e-04
		,4.7918740520e-04
		,4.8213547100e-04
		,4.8502723560e-04
		,4.8786005900e-04
		,4.9063430480e-04
		,4.9335191580e-04
		,4.9601508870e-04
		,4.9862548320e-04
		,5.0118386050e-04
		,5.0369023780e-04
		,5.0614425480e-04
		,5.0854544700e-04
		,5.1089338640e-04
		,5.1318773740e-04
		,5.1542826470e-04
		,5.1761480970e-04
		,5.1974723320e-04
		,5.2182530140e-04
		,5.2384843590e-04
		,5.2581507310e-04
		,5.2772071480e-04
		,5.2955200590e-04
		,5.3128355420e-04
		,5.3291929260e-04
		,5.3449263260e-04
		,5.3602062940e-04
		,5.3750891010e-04
		,5.3895978810e-04
		,5.4037475230e-04
		,5.4175509600e-04
		,5.4310193360e-04
		,5.4441599690e-04
		,5.4569762610e-04
		,5.4694768990e-04
		,5.4816853950e-04
		,5.4936249110e-04
		,5.5052996060e-04
		,5.5167001700e-04
		,5.5278357400e-04
		,5.5387508420e-04
		,5.5494916380e-04
		,5.5600833650e-04
		,5.5705359890e-04
		,5.5808522920e-04
		,5.5910314450e-04
		,5.6010698170e-04
		,5.6109602470e-04
		,5.6206902790e-04
		,5.6302415210e-04
		,5.6395963070e-04
		,5.6487516980e-04
		,5.6577221160e-04
    };

	real ids_value = 0;

    // 1D interpolation for ids
    analog function real interpolate_1d_ids;
		input x;
		input y;
		input z;
		input [0 : vds_width_int-1] x_points;
		input [0 : vgs_width_int-1] y_points;
		input [0 : vgd_width_int-1] z_points;
		input [0 : vds_width_int*vgs_width_int*vgd_width_int-1] ids_table;
		real x;
		real y;
		real z;
		real x_points[0 : vds_width_int-1];
		real y_points[0 : vgs_width_int-1];
		real z_points[0 : vgd_width_int-1];
		real ids_table[0 : vds_width_int*vgs_width_int*vgd_width_int-1];
        integer i;
        integer j;
        integer k;
        integer ii = 0;
        integer jj = 0;
        integer kk = 0;
        real x1, x2, ids1, ids2, dx;
        begin
			///// vds conditions /////
			if(x < x_points[0])
				ii = 0;
			else if(x >= x_points[vds_width_int - 1])
				ii = vds_width_int - 2;
			else
				for (i = 0; i < vds_width_int - 1; i = i + 1) begin
					if (x_points[i] <= x && x <= x_points[i+1])
						ii = i;
				end

			///// vgs conditions /////
			for (j = 0; j < vgs_width_int - 1; j = j + 1) begin
				if(y < y_points[0])
					jj = 0;
				else if(y_points[j] <= y && y < y_points[j+1]/2)
					jj = j;
				else if(y_points[j+1]/2 <= y && y < y_points[j+1])
					jj = j+1;
				else
					jj = jj;
			end
				if(y >= y_points[vgs_width_int - 1])
					jj = vgs_width_int - 1;

			///// vgd conditions /////
			for (k = 0; k < vgd_width_int - 1; k = k + 1) begin
				if(z < z_points[0])
					kk = 0;
				else if(z_points[k] <= z && z < z_points[k+1]/2)
					kk = k;
				else if(z_points[k+1]/2 <= z && z < z_points[k+1])
					kk = k+1;
				else
					kk = kk;
			end
			if(z >= z_points[vgd_width_int - 1])
					kk = vgd_width_int - 1;

			///// 1D interpolation for Vds /////
            x1 = x_points[ii]; x2 = x_points[ii+1];
            ids1 = ids_table[(jj*vds_width_int*vgd_width_int)+(kk*vds_width_int)+ii]; ids2 = ids_table[(jj*vds_width_int*vgd_width_int)+(kk*vds_width_int)+ii+1];
            dx = (x - x1) / (x2 - x1);
            interpolate_1d_ids = ids1 * (1 - dx) + ids2 * dx;
        end
    endfunction

	analog function real interpolate_3d_ids;
		input x;  // Vds
		input y;  // Vgs
		input z;  // Vgd
		input [0 : vds_width_int-1] x_points; // Vds grid
		input [0 : vgs_width_int-1] y_points; // Vgs grid
		input [0 : vgd_width_int-1] z_points; // Vgd grid
		input [0 : vds_width_int * vgs_width_int * vgd_width_int - 1] ids_table;

		real x, y, z;
		real x_points[0 : vds_width_int-1];
		real y_points[0 : vgs_width_int-1];
		real z_points[0 : vgd_width_int-1];
		real ids_table[0 : vds_width_int * vgs_width_int * vgd_width_int - 1];

		integer i, j, k;
		integer ii = 0, jj = 0, kk = 0;
		real x1, x2, y1, y2, z1, z2;
		real c000, c001, c010, c011, c100, c101, c110, c111;
		real dx, dy, dz;

		begin
			// Locate the indices for x (Vds)
			if (x < x_points[0])
				ii = 0;
			else if (x >= x_points[vds_width_int - 1])
				ii = vds_width_int - 2;
			else
				for (i = 0; i < vds_width_int - 1; i = i + 1) begin
					if (x_points[i] <= x && x <= x_points[i+1])
						ii = i;
				end

			// Locate the indices for y (Vgs)
			if (y < y_points[0])
				jj = 0;
			else if (y >= y_points[vgs_width_int - 1])
				jj = vgs_width_int - 2;
			else
				for (j = 0; j < vgs_width_int - 1; j = j + 1) begin
					if (y_points[j] <= y && y <= y_points[j+1])
						jj = j;
				end

			// Locate the indices for z (Vgd)
			if (z < z_points[0])
				kk = 0;
			else if (z >= z_points[vgd_width_int - 1])
				kk = vgd_width_int - 2;
			else
				for (k = 0; k < vgd_width_int - 1; k = k + 1) begin
					if (z_points[k] <= z && z <= z_points[k+1])
						kk = k;
				end

			// Define surrounding grid points
			x1 = x_points[ii]; x2 = x_points[ii+1];
			y1 = y_points[jj]; y2 = y_points[jj+1];
			z1 = z_points[kk]; z2 = z_points[kk+1];

			// Extract values from ids_table
			c000 = ids_table[(jj * vds_width_int * vgd_width_int) + (kk * vds_width_int) + ii];
			c001 = ids_table[(jj * vds_width_int * vgd_width_int) + ((kk+1) * vds_width_int) + ii];
			c010 = ids_table[((jj+1) * vds_width_int * vgd_width_int) + (kk * vds_width_int) + ii];
			c011 = ids_table[((jj+1) * vds_width_int * vgd_width_int) + ((kk+1) * vds_width_int) + ii];
			c100 = ids_table[(jj * vds_width_int * vgd_width_int) + (kk * vds_width_int) + (ii+1)];
			c101 = ids_table[(jj * vds_width_int * vgd_width_int) + ((kk+1) * vds_width_int) + (ii+1)];
			c110 = ids_table[((jj+1) * vds_width_int * vgd_width_int) + (kk * vds_width_int) + (ii+1)];
			c111 = ids_table[((jj+1) * vds_width_int * vgd_width_int) + ((kk+1) * vds_width_int) + (ii+1)];

			// Calculate weights
			dx = (x - x1) / (x2 - x1);
			dy = (y - y1) / (y2 - y1);
			dz = (z - z1) / (z2 - z1);

			// Perform trilinear interpolation
			interpolate_3d_ids =
				c000 * (1 - dx) * (1 - dy) * (1 - dz) +
				c001 * (1 - dx) * (1 - dy) * dz +
				c010 * (1 - dx) * dy * (1 - dz) +
				c011 * (1 - dx) * dy * dz +
				c100 * dx * (1 - dy) * (1 - dz) +
				c101 * dx * (1 - dy) * dz +
				c110 * dx * dy * (1 - dz) +
				c111 * dx * dy * dz;
		end
	endfunction

    analog begin
        // Compute Ids using 1D interpolation
         ids_value = interpolate_1d_ids(V(d, s), V(gs, b), V(gd, b), vds_points, vgs_points, vgd_points, table_ids);
        // ids_value = interpolate_3d_ids(V(d, s), V(gs, s), V(gd, s), vds_points, vgs_points, vgd_points, table_ids);

        // Define currents and charges
        I(d, s) <+ ids_value;
    end
endmodule
